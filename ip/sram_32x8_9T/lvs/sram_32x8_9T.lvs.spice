* NGSPICE file created from sram_32x8_9T.ext - technology: gf180mcuD

.subckt sram_32x8_9T RBL[0] RBL[1] RBL[2] RBL[3] RBL[4] RBL[5] RBL[6] RBL[7] RBL[8]
+ RBL[9] RBL[10] RBL[11] RBL[12] RBL[13] RBL[14] RBL[15] RBL[16] RBL[17] RBL[18] RBL[19]
+ RBL[20] RBL[21] RBL[22] RBL[23] RBL[24] RBL[25] RBL[26] RBL[27] RBL[28] RBL[29]
+ RBL[30] RBL[31] RBL[32] RBL[33] RBL[34] RBL[35] RBL[36] RBL[37] RBL[38] RBL[39]
+ RBL[40] RBL[41] RBL[42] RBL[43] RBL[44] RBL[45] RBL[46] RBL[47] RBL[48] RBL[49]
+ RBL[50] RBL[51] RBL[52] RBL[53] RBL[54] RBL[55] RBL[56] RBL[57] RBL[58] RBL[59]
+ RBL[60] RBL[61] RBL[62] RBL[63] RBL[64] RBL[65] RBL[66] RBL[67] RBL[68] RBL[69]
+ RBL[70] RBL[71] RBL[72] RBL[73] RBL[74] RBL[75] RBL[76] RBL[77] RBL[78] RBL[79]
+ RBL[80] RBL[81] RBL[82] RBL[83] RBL[84] RBL[85] RBL[86] RBL[87] RBL[88] RBL[89]
+ RBL[90] RBL[91] RBL[92] RBL[93] RBL[94] RBL[95] RBL[96] RBL[97] RBL[98] RBL[99]
+ RBL[100] RBL[101] RBL[102] RBL[103] RBL[104] RBL[105] RBL[106] RBL[107] RBL[108]
+ RBL[109] RBL[110] RBL[111] RBL[112] RBL[113] RBL[114] RBL[115] RBL[116] RBL[117]
+ RBL[118] RBL[119] RBL[120] RBL[121] RBL[122] RBL[123] RBL[124] RBL[125] RBL[126]
+ RBL[127] RBL[128] RBL[129] RBL[130] RBL[131] RBL[132] RBL[133] RBL[134] RBL[135]
+ RBL[136] RBL[137] RBL[138] RBL[139] RBL[140] RBL[141] RBL[142] RBL[143] RBL[144]
+ RBL[145] RBL[146] RBL[147] RBL[148] RBL[149] RBL[150] RBL[151] RBL[152] RBL[153]
+ RBL[154] RBL[155] RBL[156] RBL[157] RBL[158] RBL[159] RBL[160] RBL[161] RBL[162]
+ RBL[163] RBL[164] RBL[165] RBL[166] RBL[167] RBL[168] RBL[169] RBL[170] RBL[171]
+ RBL[172] RBL[173] RBL[174] RBL[175] RBL[176] RBL[177] RBL[178] RBL[179] RBL[180]
+ RBL[181] RBL[182] RBL[183] RBL[184] RBL[185] RBL[186] RBL[187] RBL[188] RBL[189]
+ RBL[190] RBL[191] RBL[192] RBL[193] RBL[194] RBL[195] RBL[196] RBL[197] RBL[198]
+ RBL[199] RBL[200] RBL[201] RBL[202] RBL[203] RBL[204] RBL[205] RBL[206] RBL[207]
+ RBL[208] RBL[209] RBL[210] RBL[211] RBL[212] RBL[213] RBL[214] RBL[215] RBL[216]
+ RBL[217] RBL[218] RBL[219] RBL[220] RBL[221] RBL[222] RBL[223] RBL[224] RBL[225]
+ RBL[226] RBL[227] RBL[228] RBL[229] RBL[230] RBL[231] RBL[232] RBL[233] RBL[234]
+ RBL[235] RBL[236] RBL[237] RBL[238] RBL[239] RBL[240] RBL[241] RBL[242] RBL[243]
+ RBL[244] RBL[245] RBL[246] RBL[247] RBL[248] RBL[249] RBL[250] RBL[251] RBL[252]
+ RBL[253] RBL[254] RBL[255] WBL[0] WBL[1] WBL[2] WBL[3] WBL[4] WBL[5] WBL[6] WBL[7]
+ WBLB[0] WBLB[1] WBLB[2] WBLB[3] WBLB[4] WBLB[5] WBLB[6] WBLB[7] WL[0] WL[1] WL[2]
+ WL[3] WL[4] WL[5] WL[6] WL[7] WL[8] WL[9] WL[10] WL[11] WL[12] WL[13] WL[14] WL[15]
+ WL[16] WL[17] WL[18] WL[19] WL[20] WL[21] WL[22] WL[23] WL[24] WL[25] WL[26] WL[27]
+ WL[28] WL[29] WL[30] WL[31] A[0] A[1] A[2] A[3] A[4] A[5] A[6] A[7] A[8] A[9] A[10]
+ A[11] A[12] A[13] A[14] A[15] A[16] A[17] A[18] A[19] A[20] A[21] A[22] A[23] A[24]
+ A[25] A[26] A[27] A[28] A[29] A[30] A[31] VSS VDD
X0 a_6452_1019# a_6421_513# VDD VDD pfet_03v3 ad=0.1936p pd=1.76u as=0.1496p ps=1.12u w=0.44u l=0.28u
X1 VDD a_6452_11979# a_6421_11473# VDD pfet_03v3 ad=0.1496p pd=1.12u as=0.1936p ps=1.76u w=0.44u l=0.28u
X2 VDD a_6452_13075# a_6421_12569# VDD pfet_03v3 ad=0.1496p pd=1.12u as=0.1936p ps=1.76u w=0.44u l=0.28u
X3 a_2720_1019# a_2689_513# VSS VSS nfet_03v3 ad=0.1397p pd=1.22u as=0.1108p ps=1.1u w=0.22u l=0.28u
X4 a_3964_8691# a_3933_8185# VDD VDD pfet_03v3 ad=0.1936p pd=1.76u as=0.1496p ps=1.12u w=0.44u l=0.28u
X5 a_3964_9787# a_3933_9281# VDD VDD pfet_03v3 ad=0.1936p pd=1.76u as=0.1496p ps=1.12u w=0.44u l=0.28u
X6 RBL[183] a_6421_24625# A[22] VDD pfet_03v3 ad=0.2082p pd=1.84u as=0.2024p ps=1.8u w=0.44u l=0.28u
X7 RBL[25] a_2689_3801# VSS VSS nfet_03v3 ad=0.1516p pd=1.64u as=0.1516p ps=1.64u w=0.22u l=0.28u
X8 VDD a_3964_15267# a_3933_14761# VDD pfet_03v3 ad=0.1496p pd=1.12u as=0.1936p ps=1.76u w=0.44u l=0.28u
X9 a_5799_1609# WL[1] WBLB[6] VSS nfet_03v3 ad=0.139p pd=1.215u as=0.2362p ps=2.03u w=0.32u l=0.28u
X10 a_4555_33393# WL[30] WBLB[4] VSS nfet_03v3 ad=0.139p pd=1.215u as=0.2362p ps=2.03u w=0.32u l=0.28u
X11 a_4555_32297# WL[29] WBLB[4] VSS nfet_03v3 ad=0.139p pd=1.215u as=0.2362p ps=2.03u w=0.32u l=0.28u
X12 a_3342_7595# WL[6] WBL[2] VSS nfet_03v3 ad=0.1397p pd=1.22u as=0.1706p ps=1.7u w=0.32u l=0.28u
X13 VDD a_4586_34995# a_4555_34489# VDD pfet_03v3 ad=0.1496p pd=1.12u as=0.1936p ps=1.76u w=0.44u l=0.28u
X14 VDD a_4586_33899# a_4555_33393# VDD pfet_03v3 ad=0.1496p pd=1.12u as=0.1936p ps=1.76u w=0.44u l=0.28u
X15 VSS a_4586_26227# a_4555_25721# VSS nfet_03v3 ad=0.1108p pd=1.1u as=0.139p ps=1.215u w=0.22u l=0.28u
X16 a_5830_19651# a_5799_19145# VSS VSS nfet_03v3 ad=0.1397p pd=1.22u as=0.1108p ps=1.1u w=0.22u l=0.28u
X17 a_5830_27323# a_5799_26817# VDD VDD pfet_03v3 ad=0.1936p pd=1.76u as=0.1496p ps=1.12u w=0.44u l=0.28u
X18 a_5830_18555# a_5799_18049# VSS VSS nfet_03v3 ad=0.1397p pd=1.22u as=0.1108p ps=1.1u w=0.22u l=0.28u
X19 a_5830_7595# a_5799_7089# VSS VSS nfet_03v3 ad=0.1397p pd=1.22u as=0.1108p ps=1.1u w=0.22u l=0.28u
X20 VDD a_5208_4307# a_5177_3801# VDD pfet_03v3 ad=0.1496p pd=1.12u as=0.1936p ps=1.76u w=0.44u l=0.28u
X21 a_2098_20747# WL[18] WBL[0] VSS nfet_03v3 ad=0.1397p pd=1.22u as=0.1706p ps=1.7u w=0.32u l=0.28u
X22 a_6452_30611# WL[27] WBL[7] VSS nfet_03v3 ad=0.1397p pd=1.22u as=0.1706p ps=1.7u w=0.32u l=0.28u
X23 VSS a_3342_15267# a_3311_14761# VSS nfet_03v3 ad=0.1108p pd=1.1u as=0.139p ps=1.215u w=0.22u l=0.28u
X24 RBL[187] a_3964_26227# A[23] VSS nfet_03v3 ad=0.1516p pd=1.64u as=0.1516p ps=1.64u w=0.22u l=0.28u
X25 RBL[179] a_3964_25131# A[22] VSS nfet_03v3 ad=0.1516p pd=1.64u as=0.1516p ps=1.64u w=0.22u l=0.28u
X26 VSS a_3964_9787# a_3933_9281# VSS nfet_03v3 ad=0.1108p pd=1.1u as=0.139p ps=1.215u w=0.22u l=0.28u
X27 RBL[53] a_5177_7089# VSS VSS nfet_03v3 ad=0.1516p pd=1.64u as=0.1516p ps=1.64u w=0.22u l=0.28u
X28 VSS a_5830_15267# a_5799_14761# VSS nfet_03v3 ad=0.1108p pd=1.1u as=0.139p ps=1.215u w=0.22u l=0.28u
X29 VSS a_6452_10883# a_6421_10377# VSS nfet_03v3 ad=0.1108p pd=1.1u as=0.139p ps=1.215u w=0.22u l=0.28u
X30 VSS a_6452_11979# a_6421_11473# VSS nfet_03v3 ad=0.1108p pd=1.1u as=0.139p ps=1.215u w=0.22u l=0.28u
X31 RBL[170] a_3311_23529# A[21] VDD pfet_03v3 ad=0.2082p pd=1.84u as=0.2024p ps=1.8u w=0.44u l=0.28u
X32 RBL[76] a_4555_10377# A[9] VDD pfet_03v3 ad=0.2082p pd=1.84u as=0.2024p ps=1.8u w=0.44u l=0.28u
X33 a_6452_29515# a_6421_29009# VDD VDD pfet_03v3 ad=0.1936p pd=1.76u as=0.1496p ps=1.12u w=0.44u l=0.28u
X34 a_6452_28419# a_6421_27913# VDD VDD pfet_03v3 ad=0.1936p pd=1.76u as=0.1496p ps=1.12u w=0.44u l=0.28u
X35 RBL[97] a_2720_14171# A[12] VSS nfet_03v3 ad=0.1516p pd=1.64u as=0.1516p ps=1.64u w=0.22u l=0.28u
X36 RBL[105] a_2720_15267# A[13] VSS nfet_03v3 ad=0.1516p pd=1.64u as=0.1516p ps=1.64u w=0.22u l=0.28u
X37 RBL[147] a_3933_20241# A[18] VDD pfet_03v3 ad=0.2082p pd=1.84u as=0.2024p ps=1.8u w=0.44u l=0.28u
X38 RBL[155] a_3933_21337# A[19] VDD pfet_03v3 ad=0.2082p pd=1.84u as=0.2024p ps=1.8u w=0.44u l=0.28u
X39 RBL[52] a_4555_7089# A[6] VDD pfet_03v3 ad=0.2082p pd=1.84u as=0.2024p ps=1.8u w=0.44u l=0.28u
X40 RBL[60] a_4555_8185# A[7] VDD pfet_03v3 ad=0.2082p pd=1.84u as=0.2024p ps=1.8u w=0.44u l=0.28u
X41 a_3964_8691# a_3933_8185# VSS VSS nfet_03v3 ad=0.1397p pd=1.22u as=0.1108p ps=1.1u w=0.22u l=0.28u
X42 a_6421_8185# WL[7] WBLB[7] VSS nfet_03v3 ad=0.139p pd=1.215u as=0.2362p ps=2.03u w=0.32u l=0.28u
X43 a_6421_9281# WL[8] WBLB[7] VSS nfet_03v3 ad=0.139p pd=1.215u as=0.2362p ps=2.03u w=0.32u l=0.28u
X44 RBL[88] a_2067_12569# A[11] VDD pfet_03v3 ad=0.2082p pd=1.84u as=0.2024p ps=1.8u w=0.44u l=0.28u
X45 RBL[238] a_5799_32297# A[29] VDD pfet_03v3 ad=0.2082p pd=1.84u as=0.2024p ps=1.8u w=0.44u l=0.28u
X46 RBL[230] a_5799_31201# A[28] VDD pfet_03v3 ad=0.2082p pd=1.84u as=0.2024p ps=1.8u w=0.44u l=0.28u
X47 a_2720_6499# WL[5] WBL[1] VSS nfet_03v3 ad=0.1397p pd=1.22u as=0.1706p ps=1.7u w=0.32u l=0.28u
X48 a_2720_5403# WL[4] WBL[1] VSS nfet_03v3 ad=0.1397p pd=1.22u as=0.1706p ps=1.7u w=0.32u l=0.28u
X49 RBL[78] a_5830_10883# A[9] VSS nfet_03v3 ad=0.1516p pd=1.64u as=0.1516p ps=1.64u w=0.22u l=0.28u
X50 RBL[86] a_5830_11979# A[10] VSS nfet_03v3 ad=0.1516p pd=1.64u as=0.1516p ps=1.64u w=0.22u l=0.28u
X51 a_3311_21337# WL[19] WBLB[2] VSS nfet_03v3 ad=0.139p pd=1.215u as=0.2362p ps=2.03u w=0.32u l=0.28u
X52 VSS a_5830_5403# a_5799_4897# VSS nfet_03v3 ad=0.1108p pd=1.1u as=0.139p ps=1.215u w=0.22u l=0.28u
X53 RBL[77] a_5177_10377# A[9] VDD pfet_03v3 ad=0.2082p pd=1.84u as=0.2024p ps=1.8u w=0.44u l=0.28u
X54 a_2720_33899# a_2689_33393# VSS VSS nfet_03v3 ad=0.1397p pd=1.22u as=0.1108p ps=1.1u w=0.22u l=0.28u
X55 a_2720_32803# a_2689_32297# VSS VSS nfet_03v3 ad=0.1397p pd=1.22u as=0.1108p ps=1.1u w=0.22u l=0.28u
X56 RBL[6] a_5830_1019# A[0] VSS nfet_03v3 ad=0.1516p pd=1.64u as=0.1516p ps=1.64u w=0.22u l=0.28u
X57 a_2720_9787# a_2689_9281# VSS VSS nfet_03v3 ad=0.1397p pd=1.22u as=0.1108p ps=1.1u w=0.22u l=0.28u
X58 a_3342_1019# a_3311_513# VDD VDD pfet_03v3 ad=0.1936p pd=1.76u as=0.1496p ps=1.12u w=0.44u l=0.28u
X59 RBL[247] a_6421_33393# A[30] VDD pfet_03v3 ad=0.2082p pd=1.84u as=0.2024p ps=1.8u w=0.44u l=0.28u
X60 VSS a_3342_29515# a_3311_29009# VSS nfet_03v3 ad=0.1108p pd=1.1u as=0.139p ps=1.215u w=0.22u l=0.28u
X61 a_4555_10377# WL[9] WBLB[4] VSS nfet_03v3 ad=0.139p pd=1.215u as=0.2362p ps=2.03u w=0.32u l=0.28u
X62 a_4555_11473# WL[10] WBLB[4] VSS nfet_03v3 ad=0.139p pd=1.215u as=0.2362p ps=2.03u w=0.32u l=0.28u
X63 RBL[137] a_2689_19145# VSS VSS nfet_03v3 ad=0.1516p pd=1.64u as=0.1516p ps=1.64u w=0.22u l=0.28u
X64 RBL[243] a_3964_33899# A[30] VSS nfet_03v3 ad=0.1516p pd=1.64u as=0.1516p ps=1.64u w=0.22u l=0.28u
X65 VDD a_4586_11979# a_4555_11473# VDD pfet_03v3 ad=0.1496p pd=1.12u as=0.1936p ps=1.76u w=0.44u l=0.28u
X66 VDD a_4586_13075# a_4555_12569# VDD pfet_03v3 ad=0.1496p pd=1.12u as=0.1936p ps=1.76u w=0.44u l=0.28u
X67 VDD a_3964_24035# a_3933_23529# VDD pfet_03v3 ad=0.1496p pd=1.12u as=0.1936p ps=1.76u w=0.44u l=0.28u
X68 a_3964_16363# a_3933_15857# VSS VSS nfet_03v3 ad=0.1397p pd=1.22u as=0.1108p ps=1.1u w=0.22u l=0.28u
X69 a_3964_17459# a_3933_16953# VSS VSS nfet_03v3 ad=0.1397p pd=1.22u as=0.1108p ps=1.1u w=0.22u l=0.28u
X70 VDD a_3964_22939# a_3933_22433# VDD pfet_03v3 ad=0.1496p pd=1.12u as=0.1936p ps=1.76u w=0.44u l=0.28u
X71 a_3964_26227# a_3933_25721# VDD VDD pfet_03v3 ad=0.1936p pd=1.76u as=0.1496p ps=1.12u w=0.44u l=0.28u
X72 VSS a_5830_29515# a_5799_29009# VSS nfet_03v3 ad=0.1108p pd=1.1u as=0.139p ps=1.215u w=0.22u l=0.28u
X73 RBL[118] a_5799_15857# VSS VSS nfet_03v3 ad=0.1516p pd=1.64u as=0.1516p ps=1.64u w=0.22u l=0.28u
X74 RBL[126] a_5799_16953# VSS VSS nfet_03v3 ad=0.1516p pd=1.64u as=0.1516p ps=1.64u w=0.22u l=0.28u
X75 RBL[180] a_4555_24625# A[22] VDD pfet_03v3 ad=0.2082p pd=1.84u as=0.2024p ps=1.8u w=0.44u l=0.28u
X76 VSS a_2098_9787# a_2067_9281# VSS nfet_03v3 ad=0.1108p pd=1.1u as=0.139p ps=1.215u w=0.22u l=0.28u
X77 a_5830_28419# a_5799_27913# VSS VSS nfet_03v3 ad=0.1397p pd=1.22u as=0.1108p ps=1.1u w=0.22u l=0.28u
X78 a_5830_27323# a_5799_26817# VSS VSS nfet_03v3 ad=0.1397p pd=1.22u as=0.1108p ps=1.1u w=0.22u l=0.28u
X79 RBL[50] a_3311_7089# VSS VSS nfet_03v3 ad=0.1516p pd=1.64u as=0.1516p ps=1.64u w=0.22u l=0.28u
X80 VSS a_5208_4307# a_5177_3801# VSS nfet_03v3 ad=0.1108p pd=1.1u as=0.139p ps=1.215u w=0.22u l=0.28u
X81 RBL[200] a_2067_27913# A[25] VDD pfet_03v3 ad=0.2082p pd=1.84u as=0.2024p ps=1.8u w=0.44u l=0.28u
X82 RBL[121] a_2689_16953# A[15] VDD pfet_03v3 ad=0.2082p pd=1.84u as=0.2024p ps=1.8u w=0.44u l=0.28u
X83 VDD a_2098_15267# a_2067_14761# VDD pfet_03v3 ad=0.1496p pd=1.12u as=0.1936p ps=1.76u w=0.44u l=0.28u
X84 a_2689_33393# WL[30] WBLB[1] VSS nfet_03v3 ad=0.139p pd=1.215u as=0.2362p ps=2.03u w=0.32u l=0.28u
X85 a_2689_32297# WL[29] WBLB[1] VSS nfet_03v3 ad=0.139p pd=1.215u as=0.2362p ps=2.03u w=0.32u l=0.28u
X86 a_2098_30611# WL[27] WBL[0] VSS nfet_03v3 ad=0.1397p pd=1.22u as=0.1706p ps=1.7u w=0.32u l=0.28u
X87 RBL[181] a_5177_24625# A[22] VDD pfet_03v3 ad=0.2082p pd=1.84u as=0.2024p ps=1.8u w=0.44u l=0.28u
X88 VDD a_3342_4307# a_3311_3801# VDD pfet_03v3 ad=0.1496p pd=1.12u as=0.1936p ps=1.76u w=0.44u l=0.28u
X89 a_2098_2115# a_2067_1609# VDD VDD pfet_03v3 ad=0.1936p pd=1.76u as=0.1496p ps=1.12u w=0.44u l=0.28u
X90 RBL[50] a_3342_7595# A[6] VSS nfet_03v3 ad=0.1516p pd=1.64u as=0.1516p ps=1.64u w=0.22u l=0.28u
X91 VSS a_5208_33899# a_5177_33393# VSS nfet_03v3 ad=0.1108p pd=1.1u as=0.139p ps=1.215u w=0.22u l=0.28u
X92 VSS a_5208_32803# a_5177_32297# VSS nfet_03v3 ad=0.1108p pd=1.1u as=0.139p ps=1.215u w=0.22u l=0.28u
X93 a_5208_28419# WL[25] WBL[5] VSS nfet_03v3 ad=0.1397p pd=1.22u as=0.1706p ps=1.7u w=0.32u l=0.28u
X94 a_5208_27323# WL[24] WBL[5] VSS nfet_03v3 ad=0.1397p pd=1.22u as=0.1706p ps=1.7u w=0.32u l=0.28u
X95 RBL[3] a_3964_1019# A[0] VSS nfet_03v3 ad=0.1516p pd=1.64u as=0.1516p ps=1.64u w=0.22u l=0.28u
X96 RBL[150] a_5830_20747# A[18] VSS nfet_03v3 ad=0.1516p pd=1.64u as=0.1516p ps=1.64u w=0.22u l=0.28u
X97 VSS a_4586_11979# a_4555_11473# VSS nfet_03v3 ad=0.1108p pd=1.1u as=0.139p ps=1.215u w=0.22u l=0.28u
X98 a_2720_20747# a_2689_20241# VDD VDD pfet_03v3 ad=0.1936p pd=1.76u as=0.1496p ps=1.12u w=0.44u l=0.28u
X99 VSS a_4586_10883# a_4555_10377# VSS nfet_03v3 ad=0.1108p pd=1.1u as=0.139p ps=1.215u w=0.22u l=0.28u
X100 VSS a_3964_21843# a_3933_21337# VSS nfet_03v3 ad=0.1108p pd=1.1u as=0.139p ps=1.215u w=0.22u l=0.28u
X101 VSS a_3964_22939# a_3933_22433# VSS nfet_03v3 ad=0.1108p pd=1.1u as=0.139p ps=1.215u w=0.22u l=0.28u
X102 VDD a_3964_31707# a_3933_31201# VDD pfet_03v3 ad=0.1496p pd=1.12u as=0.1936p ps=1.76u w=0.44u l=0.28u
X103 VDD a_3964_30611# a_3933_30105# VDD pfet_03v3 ad=0.1496p pd=1.12u as=0.1936p ps=1.76u w=0.44u l=0.28u
X104 a_4586_29515# a_4555_29009# VDD VDD pfet_03v3 ad=0.1936p pd=1.76u as=0.1496p ps=1.12u w=0.44u l=0.28u
X105 a_4586_28419# a_4555_27913# VDD VDD pfet_03v3 ad=0.1936p pd=1.76u as=0.1496p ps=1.12u w=0.44u l=0.28u
X106 VSS a_3342_1019# a_3311_513# VSS nfet_03v3 ad=0.1108p pd=1.1u as=0.139p ps=1.215u w=0.22u l=0.28u
X107 VDD a_2720_19651# a_2689_19145# VDD pfet_03v3 ad=0.1496p pd=1.12u as=0.1936p ps=1.76u w=0.44u l=0.28u
X108 RBL[53] a_5177_7089# A[6] VDD pfet_03v3 ad=0.2082p pd=1.84u as=0.2024p ps=1.8u w=0.44u l=0.28u
X109 RBL[61] a_5177_8185# A[7] VDD pfet_03v3 ad=0.2082p pd=1.84u as=0.2024p ps=1.8u w=0.44u l=0.28u
X110 VDD a_3342_16363# a_3311_15857# VDD pfet_03v3 ad=0.1496p pd=1.12u as=0.1936p ps=1.76u w=0.44u l=0.28u
X111 RBL[75] a_3964_10883# A[9] VSS nfet_03v3 ad=0.1516p pd=1.64u as=0.1516p ps=1.64u w=0.22u l=0.28u
X112 RBL[83] a_3964_11979# A[10] VSS nfet_03v3 ad=0.1516p pd=1.64u as=0.1516p ps=1.64u w=0.22u l=0.28u
X113 RBL[154] a_3342_21843# A[19] VSS nfet_03v3 ad=0.1516p pd=1.64u as=0.1516p ps=1.64u w=0.22u l=0.28u
X114 RBL[162] a_3342_22939# A[20] VSS nfet_03v3 ad=0.1516p pd=1.64u as=0.1516p ps=1.64u w=0.22u l=0.28u
X115 a_3933_34489# WL[31] WBLB[3] VSS nfet_03v3 ad=0.139p pd=1.215u as=0.2362p ps=2.03u w=0.32u l=0.28u
X116 RBL[74] a_3311_10377# A[9] VDD pfet_03v3 ad=0.2082p pd=1.84u as=0.2024p ps=1.8u w=0.44u l=0.28u
X117 VDD a_5830_16363# a_5799_15857# VDD pfet_03v3 ad=0.1496p pd=1.12u as=0.1936p ps=1.76u w=0.44u l=0.28u
X118 a_5208_29515# a_5177_29009# VDD VDD pfet_03v3 ad=0.1936p pd=1.76u as=0.1496p ps=1.12u w=0.44u l=0.28u
X119 a_5208_28419# a_5177_27913# VDD VDD pfet_03v3 ad=0.1936p pd=1.76u as=0.1496p ps=1.12u w=0.44u l=0.28u
X120 a_6421_29009# WL[26] WBLB[7] VSS nfet_03v3 ad=0.139p pd=1.215u as=0.2362p ps=2.03u w=0.32u l=0.28u
X121 a_5830_14171# a_5799_13665# VDD VDD pfet_03v3 ad=0.1936p pd=1.76u as=0.1496p ps=1.12u w=0.44u l=0.28u
X122 VSS a_6452_34995# a_6421_34489# VSS nfet_03v3 ad=0.1108p pd=1.1u as=0.139p ps=1.215u w=0.22u l=0.28u
X123 RBL[244] a_4555_33393# A[30] VDD pfet_03v3 ad=0.2082p pd=1.84u as=0.2024p ps=1.8u w=0.44u l=0.28u
X124 RBL[225] a_2720_31707# A[28] VSS nfet_03v3 ad=0.1516p pd=1.64u as=0.1516p ps=1.64u w=0.22u l=0.28u
X125 a_2098_7595# a_2067_7089# VSS VSS nfet_03v3 ad=0.1397p pd=1.22u as=0.1108p ps=1.1u w=0.22u l=0.28u
X126 a_4555_1609# WL[1] WBLB[4] VSS nfet_03v3 ad=0.139p pd=1.215u as=0.2362p ps=2.03u w=0.32u l=0.28u
X127 a_2689_11473# WL[10] WBLB[1] VSS nfet_03v3 ad=0.139p pd=1.215u as=0.2362p ps=2.03u w=0.32u l=0.28u
X128 a_2689_10377# WL[9] WBLB[1] VSS nfet_03v3 ad=0.139p pd=1.215u as=0.2362p ps=2.03u w=0.32u l=0.28u
X129 a_2067_21337# WL[19] WBLB[0] VSS nfet_03v3 ad=0.139p pd=1.215u as=0.2362p ps=2.03u w=0.32u l=0.28u
X130 VDD a_2098_24035# a_2067_23529# VDD pfet_03v3 ad=0.1496p pd=1.12u as=0.1936p ps=1.76u w=0.44u l=0.28u
X131 VDD a_2098_22939# a_2067_22433# VDD pfet_03v3 ad=0.1496p pd=1.12u as=0.1936p ps=1.76u w=0.44u l=0.28u
X132 a_2098_30611# a_2067_30105# VSS VSS nfet_03v3 ad=0.1397p pd=1.22u as=0.1108p ps=1.1u w=0.22u l=0.28u
X133 RBL[115] a_3933_15857# VSS VSS nfet_03v3 ad=0.1516p pd=1.64u as=0.1516p ps=1.64u w=0.22u l=0.28u
X134 RBL[123] a_3933_16953# VSS VSS nfet_03v3 ad=0.1516p pd=1.64u as=0.1516p ps=1.64u w=0.22u l=0.28u
X135 VSS a_3342_4307# a_3311_3801# VSS nfet_03v3 ad=0.1108p pd=1.1u as=0.139p ps=1.215u w=0.22u l=0.28u
X136 a_3964_3211# a_3933_2705# VDD VDD pfet_03v3 ad=0.1936p pd=1.76u as=0.1496p ps=1.12u w=0.44u l=0.28u
X137 RBL[245] a_5177_33393# A[30] VDD pfet_03v3 ad=0.2082p pd=1.84u as=0.2024p ps=1.8u w=0.44u l=0.28u
X138 RBL[61] a_5208_8691# A[7] VSS nfet_03v3 ad=0.1516p pd=1.64u as=0.1516p ps=1.64u w=0.22u l=0.28u
X139 RBL[69] a_5208_9787# A[8] VSS nfet_03v3 ad=0.1516p pd=1.64u as=0.1516p ps=1.64u w=0.22u l=0.28u
X140 VDD a_5208_20747# a_5177_20241# VDD pfet_03v3 ad=0.1496p pd=1.12u as=0.1936p ps=1.76u w=0.44u l=0.28u
X141 VDD a_2720_27323# a_2689_26817# VDD pfet_03v3 ad=0.1496p pd=1.12u as=0.1936p ps=1.76u w=0.44u l=0.28u
X142 VSS a_2720_18555# a_2689_18049# VSS nfet_03v3 ad=0.1108p pd=1.1u as=0.139p ps=1.215u w=0.22u l=0.28u
X143 VSS a_2720_19651# a_2689_19145# VSS nfet_03v3 ad=0.1108p pd=1.1u as=0.139p ps=1.215u w=0.22u l=0.28u
X144 RBL[4] a_4555_513# VSS VSS nfet_03v3 ad=0.1516p pd=1.64u as=0.1516p ps=1.64u w=0.22u l=0.28u
X145 a_3964_18555# a_3933_18049# VDD VDD pfet_03v3 ad=0.1936p pd=1.76u as=0.1496p ps=1.12u w=0.44u l=0.28u
X146 a_3964_17459# a_3933_16953# VDD VDD pfet_03v3 ad=0.1936p pd=1.76u as=0.1496p ps=1.12u w=0.44u l=0.28u
X147 RBL[50] a_3311_7089# A[6] VDD pfet_03v3 ad=0.2082p pd=1.84u as=0.2024p ps=1.8u w=0.44u l=0.28u
X148 RBL[58] a_3311_8185# A[7] VDD pfet_03v3 ad=0.2082p pd=1.84u as=0.2024p ps=1.8u w=0.44u l=0.28u
X149 RBL[178] a_3311_24625# A[22] VDD pfet_03v3 ad=0.2082p pd=1.84u as=0.2024p ps=1.8u w=0.44u l=0.28u
X150 a_5799_20241# WL[18] WBLB[6] VSS nfet_03v3 ad=0.139p pd=1.215u as=0.2362p ps=2.03u w=0.32u l=0.28u
X151 a_5177_9281# WL[8] WBLB[5] VSS nfet_03v3 ad=0.139p pd=1.215u as=0.2362p ps=2.03u w=0.32u l=0.28u
X152 a_5830_13075# a_5799_12569# VSS VSS nfet_03v3 ad=0.1397p pd=1.22u as=0.1108p ps=1.1u w=0.22u l=0.28u
X153 a_5830_14171# a_5799_13665# VSS VSS nfet_03v3 ad=0.1397p pd=1.22u as=0.1108p ps=1.1u w=0.22u l=0.28u
X154 a_5177_8185# WL[7] WBLB[5] VSS nfet_03v3 ad=0.139p pd=1.215u as=0.2362p ps=2.03u w=0.32u l=0.28u
X155 a_5830_3211# a_5799_2705# VSS VSS nfet_03v3 ad=0.1397p pd=1.22u as=0.1108p ps=1.1u w=0.22u l=0.28u
X156 a_4586_2115# WL[1] WBL[4] VSS nfet_03v3 ad=0.1397p pd=1.22u as=0.1706p ps=1.7u w=0.32u l=0.28u
X157 a_5830_2115# a_5799_1609# VSS VSS nfet_03v3 ad=0.1397p pd=1.22u as=0.1108p ps=1.1u w=0.22u l=0.28u
X158 a_3933_12569# WL[11] WBLB[3] VSS nfet_03v3 ad=0.139p pd=1.215u as=0.2362p ps=2.03u w=0.32u l=0.28u
X159 RBL[238] a_5799_32297# VSS VSS nfet_03v3 ad=0.1516p pd=1.64u as=0.1516p ps=1.64u w=0.22u l=0.28u
X160 RBL[215] a_6421_29009# VSS VSS nfet_03v3 ad=0.1516p pd=1.64u as=0.1516p ps=1.64u w=0.22u l=0.28u
X161 RBL[96] a_2067_13665# A[12] VDD pfet_03v3 ad=0.2082p pd=1.84u as=0.2024p ps=1.8u w=0.44u l=0.28u
X162 VDD a_3342_25131# a_3311_24625# VDD pfet_03v3 ad=0.1496p pd=1.12u as=0.1936p ps=1.76u w=0.44u l=0.28u
X163 VDD a_3964_1019# a_3933_513# VDD pfet_03v3 ad=0.1496p pd=1.12u as=0.1936p ps=1.76u w=0.44u l=0.28u
X164 RBL[147] a_3964_20747# A[18] VSS nfet_03v3 ad=0.1516p pd=1.64u as=0.1516p ps=1.64u w=0.22u l=0.28u
X165 RBL[218] a_3342_30611# A[27] VSS nfet_03v3 ad=0.1516p pd=1.64u as=0.1516p ps=1.64u w=0.22u l=0.28u
X166 RBL[133] a_5177_18049# VSS VSS nfet_03v3 ad=0.1516p pd=1.64u as=0.1516p ps=1.64u w=0.22u l=0.28u
X167 VDD a_2098_31707# a_2067_31201# VDD pfet_03v3 ad=0.1496p pd=1.12u as=0.1936p ps=1.76u w=0.44u l=0.28u
X168 VDD a_2098_30611# a_2067_30105# VDD pfet_03v3 ad=0.1496p pd=1.12u as=0.1936p ps=1.76u w=0.44u l=0.28u
X169 VSS a_2098_21843# a_2067_21337# VSS nfet_03v3 ad=0.1108p pd=1.1u as=0.139p ps=1.215u w=0.22u l=0.28u
X170 VSS a_2098_22939# a_2067_22433# VSS nfet_03v3 ad=0.1108p pd=1.1u as=0.139p ps=1.215u w=0.22u l=0.28u
X171 a_5830_34995# WL[31] WBL[6] VSS nfet_03v3 ad=0.1397p pd=1.22u as=0.1706p ps=1.7u w=0.32u l=0.28u
X172 VDD a_5830_25131# a_5799_24625# VDD pfet_03v3 ad=0.1496p pd=1.12u as=0.1936p ps=1.76u w=0.44u l=0.28u
X173 VSS a_5830_6499# a_5799_5993# VSS nfet_03v3 ad=0.1108p pd=1.1u as=0.139p ps=1.215u w=0.22u l=0.28u
X174 VDD a_6452_21843# a_6421_21337# VDD pfet_03v3 ad=0.1496p pd=1.12u as=0.1936p ps=1.76u w=0.44u l=0.28u
X175 a_2689_1609# WL[1] WBLB[1] VSS nfet_03v3 ad=0.139p pd=1.215u as=0.2362p ps=2.03u w=0.32u l=0.28u
X176 a_6452_15267# a_6421_14761# VSS VSS nfet_03v3 ad=0.1397p pd=1.22u as=0.1108p ps=1.1u w=0.22u l=0.28u
X177 a_3964_28419# WL[25] WBL[3] VSS nfet_03v3 ad=0.1397p pd=1.22u as=0.1706p ps=1.7u w=0.32u l=0.28u
X178 a_3964_27323# WL[24] WBL[3] VSS nfet_03v3 ad=0.1397p pd=1.22u as=0.1706p ps=1.7u w=0.32u l=0.28u
X179 a_5208_19651# WL[17] WBL[5] VSS nfet_03v3 ad=0.1397p pd=1.22u as=0.1706p ps=1.7u w=0.32u l=0.28u
X180 a_6421_3801# WL[3] WBLB[7] VSS nfet_03v3 ad=0.139p pd=1.215u as=0.2362p ps=2.03u w=0.32u l=0.28u
X181 a_6421_2705# WL[2] WBLB[7] VSS nfet_03v3 ad=0.139p pd=1.215u as=0.2362p ps=2.03u w=0.32u l=0.28u
X182 a_3342_29515# a_3311_29009# VDD VDD pfet_03v3 ad=0.1936p pd=1.76u as=0.1496p ps=1.12u w=0.44u l=0.28u
X183 a_3342_28419# a_3311_27913# VDD VDD pfet_03v3 ad=0.1936p pd=1.76u as=0.1496p ps=1.12u w=0.44u l=0.28u
X184 a_5208_8691# WL[7] WBL[5] VSS nfet_03v3 ad=0.1397p pd=1.22u as=0.1706p ps=1.7u w=0.32u l=0.28u
X185 a_5208_9787# WL[8] WBL[5] VSS nfet_03v3 ad=0.1397p pd=1.22u as=0.1706p ps=1.7u w=0.32u l=0.28u
X186 VSS a_4586_34995# a_4555_34489# VSS nfet_03v3 ad=0.1108p pd=1.1u as=0.139p ps=1.215u w=0.22u l=0.28u
X187 a_4586_29515# WL[26] WBL[4] VSS nfet_03v3 ad=0.1397p pd=1.22u as=0.1706p ps=1.7u w=0.32u l=0.28u
X188 RBL[62] a_5799_8185# VSS VSS nfet_03v3 ad=0.1516p pd=1.64u as=0.1516p ps=1.64u w=0.22u l=0.28u
X189 RBL[70] a_5799_9281# VSS VSS nfet_03v3 ad=0.1516p pd=1.64u as=0.1516p ps=1.64u w=0.22u l=0.28u
X190 VSS a_2720_28419# a_2689_27913# VSS nfet_03v3 ad=0.1108p pd=1.1u as=0.139p ps=1.215u w=0.22u l=0.28u
X191 VSS a_2720_27323# a_2689_26817# VSS nfet_03v3 ad=0.1108p pd=1.1u as=0.139p ps=1.215u w=0.22u l=0.28u
X192 a_3964_1019# a_3933_513# VDD VDD pfet_03v3 ad=0.1936p pd=1.76u as=0.1496p ps=1.12u w=0.44u l=0.28u
X193 VSS a_3342_25131# a_3311_24625# VSS nfet_03v3 ad=0.1108p pd=1.1u as=0.139p ps=1.215u w=0.22u l=0.28u
X194 VSS a_3342_24035# a_3311_23529# VSS nfet_03v3 ad=0.1108p pd=1.1u as=0.139p ps=1.215u w=0.22u l=0.28u
X195 RBL[15] a_6421_1609# VSS VSS nfet_03v3 ad=0.1516p pd=1.64u as=0.1516p ps=1.64u w=0.22u l=0.28u
X196 VDD a_3342_32803# a_3311_32297# VDD pfet_03v3 ad=0.1496p pd=1.12u as=0.1936p ps=1.76u w=0.44u l=0.28u
X197 a_5177_29009# WL[26] WBLB[5] VSS nfet_03v3 ad=0.139p pd=1.215u as=0.2362p ps=2.03u w=0.32u l=0.28u
X198 VSS a_5830_25131# a_5799_24625# VSS nfet_03v3 ad=0.1108p pd=1.1u as=0.139p ps=1.215u w=0.22u l=0.28u
X199 VSS a_5830_24035# a_5799_23529# VSS nfet_03v3 ad=0.1108p pd=1.1u as=0.139p ps=1.215u w=0.22u l=0.28u
X200 VDD a_5830_32803# a_5799_32297# VDD pfet_03v3 ad=0.1496p pd=1.12u as=0.1936p ps=1.76u w=0.44u l=0.28u
X201 VSS a_6452_20747# a_6421_20241# VSS nfet_03v3 ad=0.1108p pd=1.1u as=0.139p ps=1.215u w=0.22u l=0.28u
X202 RBL[242] a_3311_33393# A[30] VDD pfet_03v3 ad=0.2082p pd=1.84u as=0.2024p ps=1.8u w=0.44u l=0.28u
X203 a_6452_29515# a_6421_29009# VSS VSS nfet_03v3 ad=0.1397p pd=1.22u as=0.1108p ps=1.1u w=0.22u l=0.28u
X204 RBL[169] a_2720_24035# A[21] VSS nfet_03v3 ad=0.1516p pd=1.64u as=0.1516p ps=1.64u w=0.22u l=0.28u
X205 a_2720_16363# WL[14] WBL[1] VSS nfet_03v3 ad=0.1397p pd=1.22u as=0.1706p ps=1.7u w=0.32u l=0.28u
X206 a_2720_17459# WL[15] WBL[1] VSS nfet_03v3 ad=0.1397p pd=1.22u as=0.1706p ps=1.7u w=0.32u l=0.28u
X207 RBL[219] a_3933_30105# A[27] VDD pfet_03v3 ad=0.2082p pd=1.84u as=0.2024p ps=1.8u w=0.44u l=0.28u
X208 RBL[81] a_2689_11473# A[10] VDD pfet_03v3 ad=0.2082p pd=1.84u as=0.2024p ps=1.8u w=0.44u l=0.28u
X209 RBL[160] a_2067_22433# A[20] VDD pfet_03v3 ad=0.2082p pd=1.84u as=0.2024p ps=1.8u w=0.44u l=0.28u
X210 RBL[133] a_5208_18555# A[16] VSS nfet_03v3 ad=0.1516p pd=1.64u as=0.1516p ps=1.64u w=0.22u l=0.28u
X211 a_5799_30105# WL[27] WBLB[6] VSS nfet_03v3 ad=0.139p pd=1.215u as=0.2362p ps=2.03u w=0.32u l=0.28u
X212 a_5830_13075# WL[11] WBL[6] VSS nfet_03v3 ad=0.1397p pd=1.22u as=0.1706p ps=1.7u w=0.32u l=0.28u
X213 RBL[15] a_6452_2115# A[1] VSS nfet_03v3 ad=0.1516p pd=1.64u as=0.1516p ps=1.64u w=0.22u l=0.28u
X214 RBL[235] a_3933_32297# VSS VSS nfet_03v3 ad=0.1516p pd=1.64u as=0.1516p ps=1.64u w=0.22u l=0.28u
X215 RBL[130] a_3311_18049# VSS VSS nfet_03v3 ad=0.1516p pd=1.64u as=0.1516p ps=1.64u w=0.22u l=0.28u
X216 a_4555_20241# WL[18] WBLB[4] VSS nfet_03v3 ad=0.139p pd=1.215u as=0.2362p ps=2.03u w=0.32u l=0.28u
X217 RBL[209] a_2689_29009# VSS VSS nfet_03v3 ad=0.1516p pd=1.64u as=0.1516p ps=1.64u w=0.22u l=0.28u
X218 RBL[59] a_3933_8185# VSS VSS nfet_03v3 ad=0.1516p pd=1.64u as=0.1516p ps=1.64u w=0.22u l=0.28u
X219 RBL[67] a_3933_9281# VSS VSS nfet_03v3 ad=0.1516p pd=1.64u as=0.1516p ps=1.64u w=0.22u l=0.28u
X220 a_4586_15267# a_4555_14761# VSS VSS nfet_03v3 ad=0.1397p pd=1.22u as=0.1108p ps=1.1u w=0.22u l=0.28u
X221 VDD a_4586_21843# a_4555_21337# VDD pfet_03v3 ad=0.1496p pd=1.12u as=0.1936p ps=1.76u w=0.44u l=0.28u
X222 a_3964_34995# a_3933_34489# VDD VDD pfet_03v3 ad=0.1936p pd=1.76u as=0.1496p ps=1.12u w=0.44u l=0.28u
X223 a_3964_26227# a_3933_25721# VSS VSS nfet_03v3 ad=0.1397p pd=1.22u as=0.1108p ps=1.1u w=0.22u l=0.28u
X224 a_3964_33899# a_3933_33393# VDD VDD pfet_03v3 ad=0.1936p pd=1.76u as=0.1496p ps=1.12u w=0.44u l=0.28u
X225 a_5830_15267# a_5799_14761# VDD VDD pfet_03v3 ad=0.1936p pd=1.76u as=0.1496p ps=1.12u w=0.44u l=0.28u
X226 VDD a_2720_14171# a_2689_13665# VDD pfet_03v3 ad=0.1496p pd=1.12u as=0.1936p ps=1.76u w=0.44u l=0.28u
X227 RBL[103] a_6421_13665# VSS VSS nfet_03v3 ad=0.1516p pd=1.64u as=0.1516p ps=1.64u w=0.22u l=0.28u
X228 RBL[111] a_6421_14761# VSS VSS nfet_03v3 ad=0.1516p pd=1.64u as=0.1516p ps=1.64u w=0.22u l=0.28u
X229 RBL[190] a_5799_25721# VSS VSS nfet_03v3 ad=0.1516p pd=1.64u as=0.1516p ps=1.64u w=0.22u l=0.28u
X230 RBL[182] a_5799_24625# VSS VSS nfet_03v3 ad=0.1516p pd=1.64u as=0.1516p ps=1.64u w=0.22u l=0.28u
X231 a_6452_18555# WL[16] WBL[7] VSS nfet_03v3 ad=0.1397p pd=1.22u as=0.1706p ps=1.7u w=0.32u l=0.28u
X232 a_2720_24035# WL[21] WBL[1] VSS nfet_03v3 ad=0.1397p pd=1.22u as=0.1706p ps=1.7u w=0.32u l=0.28u
X233 VDD a_3342_10883# a_3311_10377# VDD pfet_03v3 ad=0.1496p pd=1.12u as=0.1936p ps=1.76u w=0.44u l=0.28u
X234 RBL[193] a_2689_26817# A[24] VDD pfet_03v3 ad=0.2082p pd=1.84u as=0.2024p ps=1.8u w=0.44u l=0.28u
X235 RBL[185] a_2689_25721# A[23] VDD pfet_03v3 ad=0.2082p pd=1.84u as=0.2024p ps=1.8u w=0.44u l=0.28u
X236 VDD a_3964_5403# a_3933_4897# VDD pfet_03v3 ad=0.1496p pd=1.12u as=0.1936p ps=1.76u w=0.44u l=0.28u
X237 RBL[23] a_6421_2705# A[2] VDD pfet_03v3 ad=0.2082p pd=1.84u as=0.2024p ps=1.8u w=0.44u l=0.28u
X238 RBL[15] a_6421_1609# A[1] VDD pfet_03v3 ad=0.2082p pd=1.84u as=0.2024p ps=1.8u w=0.44u l=0.28u
X239 VDD a_5830_10883# a_5799_10377# VDD pfet_03v3 ad=0.1496p pd=1.12u as=0.1936p ps=1.76u w=0.44u l=0.28u
X240 a_5208_15267# a_5177_14761# VSS VSS nfet_03v3 ad=0.1397p pd=1.22u as=0.1108p ps=1.1u w=0.22u l=0.28u
X241 a_6452_16363# a_6421_15857# VDD VDD pfet_03v3 ad=0.1936p pd=1.76u as=0.1496p ps=1.12u w=0.44u l=0.28u
X242 a_3964_19651# WL[17] WBL[3] VSS nfet_03v3 ad=0.1397p pd=1.22u as=0.1706p ps=1.7u w=0.32u l=0.28u
X243 a_3964_4307# a_3933_3801# VDD VDD pfet_03v3 ad=0.1936p pd=1.76u as=0.1496p ps=1.12u w=0.44u l=0.28u
X244 RBL[12] a_4586_2115# A[1] VSS nfet_03v3 ad=0.1516p pd=1.64u as=0.1516p ps=1.64u w=0.22u l=0.28u
X245 a_2098_3211# a_2067_2705# VSS VSS nfet_03v3 ad=0.1397p pd=1.22u as=0.1108p ps=1.1u w=0.22u l=0.28u
X246 a_2098_2115# a_2067_1609# VSS VSS nfet_03v3 ad=0.1397p pd=1.22u as=0.1108p ps=1.1u w=0.22u l=0.28u
X247 VDD a_2720_6499# a_2689_5993# VDD pfet_03v3 ad=0.1496p pd=1.12u as=0.1936p ps=1.76u w=0.44u l=0.28u
X248 VDD a_2720_7595# a_2689_7089# VDD pfet_03v3 ad=0.1496p pd=1.12u as=0.1936p ps=1.76u w=0.44u l=0.28u
X249 a_3342_29515# WL[26] WBL[2] VSS nfet_03v3 ad=0.1397p pd=1.22u as=0.1706p ps=1.7u w=0.32u l=0.28u
X250 VDD a_6452_8691# a_6421_8185# VDD pfet_03v3 ad=0.1496p pd=1.12u as=0.1936p ps=1.76u w=0.44u l=0.28u
X251 VDD a_6452_9787# a_6421_9281# VDD pfet_03v3 ad=0.1496p pd=1.12u as=0.1936p ps=1.76u w=0.44u l=0.28u
X252 RBL[70] a_5799_9281# A[8] VDD pfet_03v3 ad=0.2082p pd=1.84u as=0.2024p ps=1.8u w=0.44u l=0.28u
X253 a_3342_2115# WL[1] WBL[2] VSS nfet_03v3 ad=0.1397p pd=1.22u as=0.1706p ps=1.7u w=0.32u l=0.28u
X254 VSS a_4586_20747# a_4555_20241# VSS nfet_03v3 ad=0.1108p pd=1.1u as=0.139p ps=1.215u w=0.22u l=0.28u
X255 VSS a_3964_31707# a_3933_31201# VSS nfet_03v3 ad=0.1108p pd=1.1u as=0.139p ps=1.215u w=0.22u l=0.28u
X256 a_4586_29515# a_4555_29009# VSS VSS nfet_03v3 ad=0.1397p pd=1.22u as=0.1108p ps=1.1u w=0.22u l=0.28u
X257 a_2720_5403# a_2689_4897# VDD VDD pfet_03v3 ad=0.1936p pd=1.76u as=0.1496p ps=1.12u w=0.44u l=0.28u
X258 RBL[246] a_5799_33393# VSS VSS nfet_03v3 ad=0.1516p pd=1.64u as=0.1516p ps=1.64u w=0.22u l=0.28u
X259 VSS a_2720_13075# a_2689_12569# VSS nfet_03v3 ad=0.1108p pd=1.1u as=0.139p ps=1.215u w=0.22u l=0.28u
X260 VSS a_2720_14171# a_2689_13665# VSS nfet_03v3 ad=0.1108p pd=1.1u as=0.139p ps=1.215u w=0.22u l=0.28u
X261 a_6452_26227# WL[23] WBL[7] VSS nfet_03v3 ad=0.1397p pd=1.22u as=0.1706p ps=1.7u w=0.32u l=0.28u
X262 a_6452_25131# WL[22] WBL[7] VSS nfet_03v3 ad=0.1397p pd=1.22u as=0.1706p ps=1.7u w=0.32u l=0.28u
X263 VDD a_4586_1019# a_4555_513# VDD pfet_03v3 ad=0.1496p pd=1.12u as=0.1936p ps=1.76u w=0.44u l=0.28u
X264 a_6452_6499# a_6421_5993# VDD VDD pfet_03v3 ad=0.1936p pd=1.76u as=0.1496p ps=1.12u w=0.44u l=0.28u
X265 a_6452_7595# a_6421_7089# VDD VDD pfet_03v3 ad=0.1936p pd=1.76u as=0.1496p ps=1.12u w=0.44u l=0.28u
X266 a_3964_13075# a_3933_12569# VDD VDD pfet_03v3 ad=0.1936p pd=1.76u as=0.1496p ps=1.12u w=0.44u l=0.28u
X267 a_3964_11979# a_3933_11473# VDD VDD pfet_03v3 ad=0.1936p pd=1.76u as=0.1496p ps=1.12u w=0.44u l=0.28u
X268 a_5208_29515# a_5177_29009# VSS VSS nfet_03v3 ad=0.1397p pd=1.22u as=0.1108p ps=1.1u w=0.22u l=0.28u
X269 VDD a_2098_5403# a_2067_4897# VDD pfet_03v3 ad=0.1496p pd=1.12u as=0.1936p ps=1.76u w=0.44u l=0.28u
X270 a_5177_3801# WL[3] WBLB[5] VSS nfet_03v3 ad=0.139p pd=1.215u as=0.2362p ps=2.03u w=0.32u l=0.28u
X271 RBL[20] a_4555_2705# A[2] VDD pfet_03v3 ad=0.2082p pd=1.84u as=0.2024p ps=1.8u w=0.44u l=0.28u
X272 a_5177_2705# WL[2] WBLB[5] VSS nfet_03v3 ad=0.139p pd=1.215u as=0.2362p ps=2.03u w=0.32u l=0.28u
X273 RBL[12] a_4555_1609# A[1] VDD pfet_03v3 ad=0.2082p pd=1.84u as=0.2024p ps=1.8u w=0.44u l=0.28u
X274 a_5830_24035# a_5799_23529# VDD VDD pfet_03v3 ad=0.1936p pd=1.76u as=0.1496p ps=1.12u w=0.44u l=0.28u
X275 a_5830_22939# a_5799_22433# VDD VDD pfet_03v3 ad=0.1936p pd=1.76u as=0.1496p ps=1.12u w=0.44u l=0.28u
X276 a_4555_30105# WL[27] WBLB[4] VSS nfet_03v3 ad=0.139p pd=1.215u as=0.2362p ps=2.03u w=0.32u l=0.28u
X277 a_3964_8691# WL[7] WBL[3] VSS nfet_03v3 ad=0.1397p pd=1.22u as=0.1706p ps=1.7u w=0.32u l=0.28u
X278 RBL[56] a_2067_8185# VSS VSS nfet_03v3 ad=0.1516p pd=1.64u as=0.1516p ps=1.64u w=0.22u l=0.28u
X279 RBL[56] a_2098_8691# A[7] VSS nfet_03v3 ad=0.1516p pd=1.64u as=0.1516p ps=1.64u w=0.22u l=0.28u
X280 a_3964_9787# WL[8] WBL[3] VSS nfet_03v3 ad=0.1397p pd=1.22u as=0.1706p ps=1.7u w=0.32u l=0.28u
X281 RBL[64] a_2067_9281# VSS VSS nfet_03v3 ad=0.1516p pd=1.64u as=0.1516p ps=1.64u w=0.22u l=0.28u
X282 RBL[64] a_2098_9787# A[8] VSS nfet_03v3 ad=0.1516p pd=1.64u as=0.1516p ps=1.64u w=0.22u l=0.28u
X283 VSS a_3964_5403# a_3933_4897# VSS nfet_03v3 ad=0.1108p pd=1.1u as=0.139p ps=1.215u w=0.22u l=0.28u
X284 a_2689_20241# WL[18] WBLB[1] VSS nfet_03v3 ad=0.139p pd=1.215u as=0.2362p ps=2.03u w=0.32u l=0.28u
X285 RBL[249] a_2689_34489# A[31] VDD pfet_03v3 ad=0.2082p pd=1.84u as=0.2024p ps=1.8u w=0.44u l=0.28u
X286 a_2098_18555# WL[16] WBL[0] VSS nfet_03v3 ad=0.1397p pd=1.22u as=0.1706p ps=1.7u w=0.32u l=0.28u
X287 VSS a_6452_8691# a_6421_8185# VSS nfet_03v3 ad=0.1108p pd=1.1u as=0.139p ps=1.215u w=0.22u l=0.28u
X288 a_6452_25131# a_6421_24625# VDD VDD pfet_03v3 ad=0.1936p pd=1.76u as=0.1496p ps=1.12u w=0.44u l=0.28u
X289 RBL[187] a_3933_25721# VSS VSS nfet_03v3 ad=0.1516p pd=1.64u as=0.1516p ps=1.64u w=0.22u l=0.28u
X290 RBL[179] a_3933_24625# VSS VSS nfet_03v3 ad=0.1516p pd=1.64u as=0.1516p ps=1.64u w=0.22u l=0.28u
X291 a_3964_4307# a_3933_3801# VSS VSS nfet_03v3 ad=0.1397p pd=1.22u as=0.1108p ps=1.1u w=0.22u l=0.28u
X292 a_5208_14171# WL[12] WBL[5] VSS nfet_03v3 ad=0.1397p pd=1.22u as=0.1706p ps=1.7u w=0.32u l=0.28u
X293 a_5208_15267# WL[13] WBL[5] VSS nfet_03v3 ad=0.1397p pd=1.22u as=0.1706p ps=1.7u w=0.32u l=0.28u
X294 VDD a_4586_8691# a_4555_8185# VDD pfet_03v3 ad=0.1496p pd=1.12u as=0.1936p ps=1.76u w=0.44u l=0.28u
X295 VDD a_4586_9787# a_4555_9281# VDD pfet_03v3 ad=0.1496p pd=1.12u as=0.1936p ps=1.76u w=0.44u l=0.28u
X296 a_4586_1019# a_4555_513# VDD VDD pfet_03v3 ad=0.1936p pd=1.76u as=0.1496p ps=1.12u w=0.44u l=0.28u
X297 RBL[97] a_2689_13665# VSS VSS nfet_03v3 ad=0.1516p pd=1.64u as=0.1516p ps=1.64u w=0.22u l=0.28u
X298 RBL[105] a_2689_14761# VSS VSS nfet_03v3 ad=0.1516p pd=1.64u as=0.1516p ps=1.64u w=0.22u l=0.28u
X299 a_3342_15267# a_3311_14761# VSS VSS nfet_03v3 ad=0.1397p pd=1.22u as=0.1108p ps=1.1u w=0.22u l=0.28u
X300 a_5208_4307# WL[3] WBL[5] VSS nfet_03v3 ad=0.1397p pd=1.22u as=0.1706p ps=1.7u w=0.32u l=0.28u
X301 a_5208_3211# WL[2] WBL[5] VSS nfet_03v3 ad=0.1397p pd=1.22u as=0.1706p ps=1.7u w=0.32u l=0.28u
X302 RBL[9] a_2720_2115# A[1] VSS nfet_03v3 ad=0.1516p pd=1.64u as=0.1516p ps=1.64u w=0.22u l=0.28u
X303 a_3964_10883# a_3933_10377# VSS VSS nfet_03v3 ad=0.1397p pd=1.22u as=0.1108p ps=1.1u w=0.22u l=0.28u
X304 a_3964_11979# a_3933_11473# VSS VSS nfet_03v3 ad=0.1397p pd=1.22u as=0.1108p ps=1.1u w=0.22u l=0.28u
X305 a_4586_16363# a_4555_15857# VDD VDD pfet_03v3 ad=0.1936p pd=1.76u as=0.1496p ps=1.12u w=0.44u l=0.28u
X306 a_4586_6499# a_4555_5993# VDD VDD pfet_03v3 ad=0.1936p pd=1.76u as=0.1496p ps=1.12u w=0.44u l=0.28u
X307 a_4586_7595# a_4555_7089# VDD VDD pfet_03v3 ad=0.1936p pd=1.76u as=0.1496p ps=1.12u w=0.44u l=0.28u
X308 RBL[78] a_5799_10377# VSS VSS nfet_03v3 ad=0.1516p pd=1.64u as=0.1516p ps=1.64u w=0.22u l=0.28u
X309 RBL[86] a_5799_11473# VSS VSS nfet_03v3 ad=0.1516p pd=1.64u as=0.1516p ps=1.64u w=0.22u l=0.28u
X310 a_2720_5403# a_2689_4897# VSS VSS nfet_03v3 ad=0.1397p pd=1.22u as=0.1108p ps=1.1u w=0.22u l=0.28u
X311 a_2098_19651# a_2067_19145# VDD VDD pfet_03v3 ad=0.1936p pd=1.76u as=0.1496p ps=1.12u w=0.44u l=0.28u
X312 a_5830_21843# a_5799_21337# VSS VSS nfet_03v3 ad=0.1397p pd=1.22u as=0.1108p ps=1.1u w=0.22u l=0.28u
X313 a_5830_22939# a_5799_22433# VSS VSS nfet_03v3 ad=0.1397p pd=1.22u as=0.1108p ps=1.1u w=0.22u l=0.28u
X314 a_5830_31707# a_5799_31201# VDD VDD pfet_03v3 ad=0.1936p pd=1.76u as=0.1496p ps=1.12u w=0.44u l=0.28u
X315 a_5830_30611# a_5799_30105# VDD VDD pfet_03v3 ad=0.1936p pd=1.76u as=0.1496p ps=1.12u w=0.44u l=0.28u
X316 RBL[231] a_6421_31201# VSS VSS nfet_03v3 ad=0.1516p pd=1.64u as=0.1516p ps=1.64u w=0.22u l=0.28u
X317 a_3933_21337# WL[19] WBLB[3] VSS nfet_03v3 ad=0.139p pd=1.215u as=0.2362p ps=2.03u w=0.32u l=0.28u
X318 a_5208_16363# a_5177_15857# VDD VDD pfet_03v3 ad=0.1936p pd=1.76u as=0.1496p ps=1.12u w=0.44u l=0.28u
X319 a_6421_15857# WL[14] WBLB[7] VSS nfet_03v3 ad=0.139p pd=1.215u as=0.2362p ps=2.03u w=0.32u l=0.28u
X320 a_6421_16953# WL[15] WBLB[7] VSS nfet_03v3 ad=0.139p pd=1.215u as=0.2362p ps=2.03u w=0.32u l=0.28u
X321 VSS a_2098_31707# a_2067_31201# VSS nfet_03v3 ad=0.1108p pd=1.1u as=0.139p ps=1.215u w=0.22u l=0.28u
X322 RBL[205] a_5177_27913# VSS VSS nfet_03v3 ad=0.1516p pd=1.64u as=0.1516p ps=1.64u w=0.22u l=0.28u
X323 RBL[197] a_5177_26817# VSS VSS nfet_03v3 ad=0.1516p pd=1.64u as=0.1516p ps=1.64u w=0.22u l=0.28u
X324 a_2098_26227# WL[23] WBL[0] VSS nfet_03v3 ad=0.1397p pd=1.22u as=0.1706p ps=1.7u w=0.32u l=0.28u
X325 a_2098_25131# WL[22] WBL[0] VSS nfet_03v3 ad=0.1397p pd=1.22u as=0.1706p ps=1.7u w=0.32u l=0.28u
X326 a_6452_25131# a_6421_24625# VSS VSS nfet_03v3 ad=0.1397p pd=1.22u as=0.1108p ps=1.1u w=0.22u l=0.28u
X327 a_6452_24035# a_6421_23529# VSS VSS nfet_03v3 ad=0.1397p pd=1.22u as=0.1108p ps=1.1u w=0.22u l=0.28u
X328 a_6452_32803# a_6421_32297# VDD VDD pfet_03v3 ad=0.1936p pd=1.76u as=0.1496p ps=1.12u w=0.44u l=0.28u
X329 VSS a_2098_5403# a_2067_4897# VSS nfet_03v3 ad=0.1108p pd=1.1u as=0.139p ps=1.215u w=0.22u l=0.28u
X330 RBL[243] a_3933_33393# VSS VSS nfet_03v3 ad=0.1516p pd=1.64u as=0.1516p ps=1.64u w=0.22u l=0.28u
X331 a_5208_22939# WL[20] WBL[5] VSS nfet_03v3 ad=0.1397p pd=1.22u as=0.1706p ps=1.7u w=0.32u l=0.28u
X332 VSS a_4586_8691# a_4555_8185# VSS nfet_03v3 ad=0.1108p pd=1.1u as=0.139p ps=1.215u w=0.22u l=0.28u
X333 a_3342_29515# a_3311_29009# VSS VSS nfet_03v3 ad=0.1397p pd=1.22u as=0.1108p ps=1.1u w=0.22u l=0.28u
X334 VDD a_2720_15267# a_2689_14761# VDD pfet_03v3 ad=0.1496p pd=1.12u as=0.1936p ps=1.76u w=0.44u l=0.28u
X335 a_2689_30105# WL[27] WBLB[1] VSS nfet_03v3 ad=0.139p pd=1.215u as=0.2362p ps=2.03u w=0.32u l=0.28u
X336 a_2098_27323# a_2067_26817# VDD VDD pfet_03v3 ad=0.1936p pd=1.76u as=0.1496p ps=1.12u w=0.44u l=0.28u
X337 RBL[21] a_5177_2705# A[2] VDD pfet_03v3 ad=0.2082p pd=1.84u as=0.2024p ps=1.8u w=0.44u l=0.28u
X338 RBL[13] a_5177_1609# A[1] VDD pfet_03v3 ad=0.2082p pd=1.84u as=0.2024p ps=1.8u w=0.44u l=0.28u
X339 a_2098_18555# a_2067_18049# VSS VSS nfet_03v3 ad=0.1397p pd=1.22u as=0.1108p ps=1.1u w=0.22u l=0.28u
X340 RBL[128] a_2098_18555# A[16] VSS nfet_03v3 ad=0.1516p pd=1.64u as=0.1516p ps=1.64u w=0.22u l=0.28u
X341 a_2098_19651# a_2067_19145# VSS VSS nfet_03v3 ad=0.1397p pd=1.22u as=0.1108p ps=1.1u w=0.22u l=0.28u
X342 a_3311_27913# WL[25] WBLB[2] VSS nfet_03v3 ad=0.139p pd=1.215u as=0.2362p ps=2.03u w=0.32u l=0.28u
X343 a_3311_26817# WL[24] WBLB[2] VSS nfet_03v3 ad=0.139p pd=1.215u as=0.2362p ps=2.03u w=0.32u l=0.28u
X344 VSS a_3342_33899# a_3311_33393# VSS nfet_03v3 ad=0.1108p pd=1.1u as=0.139p ps=1.215u w=0.22u l=0.28u
X345 VSS a_3342_32803# a_3311_32297# VSS nfet_03v3 ad=0.1108p pd=1.1u as=0.139p ps=1.215u w=0.22u l=0.28u
X346 RBL[38] a_5830_5403# A[4] VSS nfet_03v3 ad=0.1516p pd=1.64u as=0.1516p ps=1.64u w=0.22u l=0.28u
X347 RBL[46] a_5830_6499# A[5] VSS nfet_03v3 ad=0.1516p pd=1.64u as=0.1516p ps=1.64u w=0.22u l=0.28u
X348 a_6421_23529# WL[21] WBLB[7] VSS nfet_03v3 ad=0.139p pd=1.215u as=0.2362p ps=2.03u w=0.32u l=0.28u
X349 RBL[253] a_5177_34489# a_5421_35171# VSS nfet_03v3 ad=0.1516p pd=1.64u as=0.1516p ps=1.64u w=0.22u l=0.28u
X350 VSS a_5830_33899# a_5799_33393# VSS nfet_03v3 ad=0.1108p pd=1.1u as=0.139p ps=1.215u w=0.22u l=0.28u
X351 a_4586_25131# a_4555_24625# VDD VDD pfet_03v3 ad=0.1936p pd=1.76u as=0.1496p ps=1.12u w=0.44u l=0.28u
X352 VSS a_5830_32803# a_5799_32297# VSS nfet_03v3 ad=0.1108p pd=1.1u as=0.139p ps=1.215u w=0.22u l=0.28u
X353 RBL[64] a_2067_9281# A[8] VDD pfet_03v3 ad=0.2082p pd=1.84u as=0.2024p ps=1.8u w=0.44u l=0.28u
X354 VSS a_6452_30611# a_6421_30105# VSS nfet_03v3 ad=0.1108p pd=1.1u as=0.139p ps=1.215u w=0.22u l=0.28u
X355 RBL[150] a_5799_20241# VSS VSS nfet_03v3 ad=0.1516p pd=1.64u as=0.1516p ps=1.64u w=0.22u l=0.28u
X356 RBL[145] a_2689_20241# A[18] VDD pfet_03v3 ad=0.2082p pd=1.84u as=0.2024p ps=1.8u w=0.44u l=0.28u
X357 RBL[153] a_2689_21337# A[19] VDD pfet_03v3 ad=0.2082p pd=1.84u as=0.2024p ps=1.8u w=0.44u l=0.28u
X358 RBL[232] a_2067_32297# A[29] VDD pfet_03v3 ad=0.2082p pd=1.84u as=0.2024p ps=1.8u w=0.44u l=0.28u
X359 RBL[224] a_2067_31201# A[28] VDD pfet_03v3 ad=0.2082p pd=1.84u as=0.2024p ps=1.8u w=0.44u l=0.28u
X360 RBL[205] a_5208_28419# A[25] VSS nfet_03v3 ad=0.1516p pd=1.64u as=0.1516p ps=1.64u w=0.22u l=0.28u
X361 RBL[197] a_5208_27323# A[24] VSS nfet_03v3 ad=0.1516p pd=1.64u as=0.1516p ps=1.64u w=0.22u l=0.28u
X362 a_5830_21843# WL[19] WBL[6] VSS nfet_03v3 ad=0.1397p pd=1.22u as=0.1706p ps=1.7u w=0.32u l=0.28u
X363 a_5208_25131# a_5177_24625# VDD VDD pfet_03v3 ad=0.1936p pd=1.76u as=0.1496p ps=1.12u w=0.44u l=0.28u
X364 a_6452_10883# a_6421_10377# VDD VDD pfet_03v3 ad=0.1936p pd=1.76u as=0.1496p ps=1.12u w=0.44u l=0.28u
X365 RBL[75] a_3933_10377# VSS VSS nfet_03v3 ad=0.1516p pd=1.64u as=0.1516p ps=1.64u w=0.22u l=0.28u
X366 RBL[83] a_3933_11473# VSS VSS nfet_03v3 ad=0.1516p pd=1.64u as=0.1516p ps=1.64u w=0.22u l=0.28u
X367 RBL[138] a_3342_19651# A[17] VSS nfet_03v3 ad=0.1516p pd=1.64u as=0.1516p ps=1.64u w=0.22u l=0.28u
X368 a_3964_14171# WL[12] WBL[3] VSS nfet_03v3 ad=0.1397p pd=1.22u as=0.1706p ps=1.7u w=0.32u l=0.28u
X369 a_3964_15267# WL[13] WBL[3] VSS nfet_03v3 ad=0.1397p pd=1.22u as=0.1706p ps=1.7u w=0.32u l=0.28u
X370 a_5208_6499# a_5177_5993# VDD VDD pfet_03v3 ad=0.1936p pd=1.76u as=0.1496p ps=1.12u w=0.44u l=0.28u
X371 a_5208_7595# a_5177_7089# VDD VDD pfet_03v3 ad=0.1936p pd=1.76u as=0.1496p ps=1.12u w=0.44u l=0.28u
X372 RBL[29] a_5208_4307# A[3] VSS nfet_03v3 ad=0.1516p pd=1.64u as=0.1516p ps=1.64u w=0.22u l=0.28u
X373 VDD a_2720_2115# a_2689_1609# VDD pfet_03v3 ad=0.1496p pd=1.12u as=0.1936p ps=1.76u w=0.44u l=0.28u
X374 RBL[1] a_2689_513# VSS VSS nfet_03v3 ad=0.1516p pd=1.64u as=0.1516p ps=1.64u w=0.22u l=0.28u
X375 RBL[119] a_6452_16363# A[14] VSS nfet_03v3 ad=0.1516p pd=1.64u as=0.1516p ps=1.64u w=0.22u l=0.28u
X376 RBL[127] a_6452_17459# A[15] VSS nfet_03v3 ad=0.1516p pd=1.64u as=0.1516p ps=1.64u w=0.22u l=0.28u
X377 a_3342_16363# a_3311_15857# VDD VDD pfet_03v3 ad=0.1936p pd=1.76u as=0.1496p ps=1.12u w=0.44u l=0.28u
X378 RBL[225] a_2689_31201# VSS VSS nfet_03v3 ad=0.1516p pd=1.64u as=0.1516p ps=1.64u w=0.22u l=0.28u
X379 RBL[202] a_3311_27913# VSS VSS nfet_03v3 ad=0.1516p pd=1.64u as=0.1516p ps=1.64u w=0.22u l=0.28u
X380 RBL[194] a_3311_26817# VSS VSS nfet_03v3 ad=0.1516p pd=1.64u as=0.1516p ps=1.64u w=0.22u l=0.28u
X381 RBL[18] a_3311_2705# A[2] VDD pfet_03v3 ad=0.2082p pd=1.84u as=0.2024p ps=1.8u w=0.44u l=0.28u
X382 RBL[10] a_3311_1609# A[1] VDD pfet_03v3 ad=0.2082p pd=1.84u as=0.2024p ps=1.8u w=0.44u l=0.28u
X383 VDD a_6452_3211# a_6421_2705# VDD pfet_03v3 ad=0.1496p pd=1.12u as=0.1936p ps=1.76u w=0.44u l=0.28u
X384 a_4586_16363# WL[14] WBL[4] VSS nfet_03v3 ad=0.1397p pd=1.22u as=0.1706p ps=1.7u w=0.32u l=0.28u
X385 a_4586_17459# WL[15] WBL[4] VSS nfet_03v3 ad=0.1397p pd=1.22u as=0.1706p ps=1.7u w=0.32u l=0.28u
X386 a_3964_34995# a_3933_34489# VSS VSS nfet_03v3 ad=0.1397p pd=1.22u as=0.1108p ps=1.1u w=0.22u l=0.28u
X387 a_4586_32803# a_4555_32297# VDD VDD pfet_03v3 ad=0.1936p pd=1.76u as=0.1496p ps=1.12u w=0.44u l=0.28u
X388 a_4586_25131# a_4555_24625# VSS VSS nfet_03v3 ad=0.1397p pd=1.22u as=0.1108p ps=1.1u w=0.22u l=0.28u
X389 a_4586_24035# a_4555_23529# VSS VSS nfet_03v3 ad=0.1397p pd=1.22u as=0.1108p ps=1.1u w=0.22u l=0.28u
X390 RBL[43] a_3964_6499# A[5] VSS nfet_03v3 ad=0.1516p pd=1.64u as=0.1516p ps=1.64u w=0.22u l=0.28u
X391 RBL[35] a_3964_5403# A[4] VSS nfet_03v3 ad=0.1516p pd=1.64u as=0.1516p ps=1.64u w=0.22u l=0.28u
X392 RBL[112] a_2067_15857# VSS VSS nfet_03v3 ad=0.1516p pd=1.64u as=0.1516p ps=1.64u w=0.22u l=0.28u
X393 RBL[120] a_2067_16953# VSS VSS nfet_03v3 ad=0.1516p pd=1.64u as=0.1516p ps=1.64u w=0.22u l=0.28u
X394 a_2720_33899# WL[30] WBL[1] VSS nfet_03v3 ad=0.1397p pd=1.22u as=0.1706p ps=1.7u w=0.32u l=0.28u
X395 a_2720_32803# WL[29] WBL[1] VSS nfet_03v3 ad=0.1397p pd=1.22u as=0.1706p ps=1.7u w=0.32u l=0.28u
X396 RBL[175] a_6421_23529# VSS VSS nfet_03v3 ad=0.1516p pd=1.64u as=0.1516p ps=1.64u w=0.22u l=0.28u
X397 VDD a_2720_24035# a_2689_23529# VDD pfet_03v3 ad=0.1496p pd=1.12u as=0.1936p ps=1.76u w=0.44u l=0.28u
X398 a_2720_16363# a_2689_15857# VSS VSS nfet_03v3 ad=0.1397p pd=1.22u as=0.1108p ps=1.1u w=0.22u l=0.28u
X399 a_2720_17459# a_2689_16953# VSS VSS nfet_03v3 ad=0.1397p pd=1.22u as=0.1108p ps=1.1u w=0.22u l=0.28u
X400 VDD a_2720_22939# a_2689_22433# VDD pfet_03v3 ad=0.1496p pd=1.12u as=0.1936p ps=1.76u w=0.44u l=0.28u
X401 a_2098_28419# a_2067_27913# VSS VSS nfet_03v3 ad=0.1397p pd=1.22u as=0.1108p ps=1.1u w=0.22u l=0.28u
X402 a_2098_27323# a_2067_26817# VSS VSS nfet_03v3 ad=0.1397p pd=1.22u as=0.1108p ps=1.1u w=0.22u l=0.28u
X403 a_2720_26227# a_2689_25721# VDD VDD pfet_03v3 ad=0.1936p pd=1.76u as=0.1496p ps=1.12u w=0.44u l=0.28u
X404 a_6452_2115# a_6421_1609# VDD VDD pfet_03v3 ad=0.1936p pd=1.76u as=0.1496p ps=1.12u w=0.44u l=0.28u
X405 a_2098_1019# a_2067_513# VDD VDD pfet_03v3 ad=0.1936p pd=1.76u as=0.1496p ps=1.12u w=0.44u l=0.28u
X406 VDD a_3342_20747# a_3311_20241# VDD pfet_03v3 ad=0.1496p pd=1.12u as=0.1936p ps=1.76u w=0.44u l=0.28u
X407 a_3933_7089# WL[6] WBLB[3] VSS nfet_03v3 ad=0.139p pd=1.215u as=0.2362p ps=2.03u w=0.32u l=0.28u
X408 a_5177_15857# WL[14] WBLB[5] VSS nfet_03v3 ad=0.139p pd=1.215u as=0.2362p ps=2.03u w=0.32u l=0.28u
X409 a_5177_16953# WL[15] WBLB[5] VSS nfet_03v3 ad=0.139p pd=1.215u as=0.2362p ps=2.03u w=0.32u l=0.28u
X410 RBL[116] a_4555_15857# VSS VSS nfet_03v3 ad=0.1516p pd=1.64u as=0.1516p ps=1.64u w=0.22u l=0.28u
X411 RBL[124] a_4555_16953# VSS VSS nfet_03v3 ad=0.1516p pd=1.64u as=0.1516p ps=1.64u w=0.22u l=0.28u
X412 VSS a_3964_6499# a_3933_5993# VSS nfet_03v3 ad=0.1108p pd=1.1u as=0.139p ps=1.215u w=0.22u l=0.28u
X413 RBL[253] a_5208_34995# A[31] VSS nfet_03v3 ad=0.1516p pd=1.64u as=0.1516p ps=1.64u w=0.22u l=0.28u
X414 RBL[21] a_5177_2705# VSS VSS nfet_03v3 ad=0.1516p pd=1.64u as=0.1516p ps=1.64u w=0.22u l=0.28u
X415 RBL[93] a_5177_12569# VSS VSS nfet_03v3 ad=0.1516p pd=1.64u as=0.1516p ps=1.64u w=0.22u l=0.28u
X416 VDD a_5830_20747# a_5799_20241# VDD pfet_03v3 ad=0.1496p pd=1.12u as=0.1936p ps=1.76u w=0.44u l=0.28u
X417 a_5208_25131# a_5177_24625# VSS VSS nfet_03v3 ad=0.1397p pd=1.22u as=0.1108p ps=1.1u w=0.22u l=0.28u
X418 a_5208_24035# a_5177_23529# VSS VSS nfet_03v3 ad=0.1397p pd=1.22u as=0.1108p ps=1.1u w=0.22u l=0.28u
X419 a_5208_32803# a_5177_32297# VDD VDD pfet_03v3 ad=0.1936p pd=1.76u as=0.1496p ps=1.12u w=0.44u l=0.28u
X420 a_3964_22939# WL[20] WBL[3] VSS nfet_03v3 ad=0.1397p pd=1.22u as=0.1706p ps=1.7u w=0.32u l=0.28u
X421 a_5799_18049# WL[16] WBLB[6] VSS nfet_03v3 ad=0.139p pd=1.215u as=0.2362p ps=2.03u w=0.32u l=0.28u
X422 a_3964_4307# WL[3] WBL[3] VSS nfet_03v3 ad=0.1397p pd=1.22u as=0.1706p ps=1.7u w=0.32u l=0.28u
X423 a_3964_3211# WL[2] WBL[3] VSS nfet_03v3 ad=0.1397p pd=1.22u as=0.1706p ps=1.7u w=0.32u l=0.28u
X424 RBL[131] a_3933_18049# A[16] VDD pfet_03v3 ad=0.2082p pd=1.84u as=0.2024p ps=1.8u w=0.44u l=0.28u
X425 RBL[139] a_3933_19145# A[17] VDD pfet_03v3 ad=0.2082p pd=1.84u as=0.2024p ps=1.8u w=0.44u l=0.28u
X426 a_3342_6499# a_3311_5993# VDD VDD pfet_03v3 ad=0.1936p pd=1.76u as=0.1496p ps=1.12u w=0.44u l=0.28u
X427 VSS a_2720_7595# a_2689_7089# VSS nfet_03v3 ad=0.1108p pd=1.1u as=0.139p ps=1.215u w=0.22u l=0.28u
X428 a_3342_7595# a_3311_7089# VDD VDD pfet_03v3 ad=0.1936p pd=1.76u as=0.1496p ps=1.12u w=0.44u l=0.28u
X429 RBL[250] a_3311_34489# a_3555_35171# VSS nfet_03v3 ad=0.1516p pd=1.64u as=0.1516p ps=1.64u w=0.22u l=0.28u
X430 RBL[214] a_5799_29009# A[26] VDD pfet_03v3 ad=0.2082p pd=1.84u as=0.2024p ps=1.8u w=0.44u l=0.28u
X431 VSS a_4586_30611# a_4555_30105# VSS nfet_03v3 ad=0.1108p pd=1.1u as=0.139p ps=1.215u w=0.22u l=0.28u
X432 a_4586_24035# WL[21] WBL[4] VSS nfet_03v3 ad=0.1397p pd=1.22u as=0.1706p ps=1.7u w=0.32u l=0.28u
X433 a_3311_5993# WL[5] WBLB[2] VSS nfet_03v3 ad=0.139p pd=1.215u as=0.2362p ps=2.03u w=0.32u l=0.28u
X434 a_3311_4897# WL[4] WBLB[2] VSS nfet_03v3 ad=0.139p pd=1.215u as=0.2362p ps=2.03u w=0.32u l=0.28u
X435 a_2720_6499# a_2689_5993# VSS VSS nfet_03v3 ad=0.1397p pd=1.22u as=0.1108p ps=1.1u w=0.22u l=0.28u
X436 RBL[147] a_3933_20241# VSS VSS nfet_03v3 ad=0.1516p pd=1.64u as=0.1516p ps=1.64u w=0.22u l=0.28u
X437 a_2067_27913# WL[25] WBLB[0] VSS nfet_03v3 ad=0.139p pd=1.215u as=0.2362p ps=2.03u w=0.32u l=0.28u
X438 a_2067_26817# WL[24] WBLB[0] VSS nfet_03v3 ad=0.139p pd=1.215u as=0.2362p ps=2.03u w=0.32u l=0.28u
X439 a_5177_513# WL[0] WBLB[5] VSS nfet_03v3 ad=0.139p pd=1.215u as=0.2362p ps=2.03u w=0.32u l=0.28u
X440 a_3311_19145# WL[17] WBLB[2] VSS nfet_03v3 ad=0.139p pd=1.215u as=0.2362p ps=2.03u w=0.32u l=0.28u
X441 RBL[30] a_5799_3801# VSS VSS nfet_03v3 ad=0.1516p pd=1.64u as=0.1516p ps=1.64u w=0.22u l=0.28u
X442 VDD a_4586_3211# a_4555_2705# VDD pfet_03v3 ad=0.1496p pd=1.12u as=0.1936p ps=1.76u w=0.44u l=0.28u
X443 VSS a_2720_21843# a_2689_21337# VSS nfet_03v3 ad=0.1108p pd=1.1u as=0.139p ps=1.215u w=0.22u l=0.28u
X444 VSS a_2720_22939# a_2689_22433# VSS nfet_03v3 ad=0.1108p pd=1.1u as=0.139p ps=1.215u w=0.22u l=0.28u
X445 a_6452_34995# WL[31] WBL[7] VSS nfet_03v3 ad=0.1397p pd=1.22u as=0.1706p ps=1.7u w=0.32u l=0.28u
X446 VDD a_2720_31707# a_2689_31201# VDD pfet_03v3 ad=0.1496p pd=1.12u as=0.1936p ps=1.76u w=0.44u l=0.28u
X447 VDD a_2720_30611# a_2689_30105# VDD pfet_03v3 ad=0.1496p pd=1.12u as=0.1936p ps=1.76u w=0.44u l=0.28u
X448 a_6452_7595# a_6421_7089# VSS VSS nfet_03v3 ad=0.1397p pd=1.22u as=0.1108p ps=1.1u w=0.22u l=0.28u
X449 a_5177_23529# WL[21] WBLB[5] VSS nfet_03v3 ad=0.139p pd=1.215u as=0.2362p ps=2.03u w=0.32u l=0.28u
X450 VDD a_5208_26227# a_5177_25721# VDD pfet_03v3 ad=0.1496p pd=1.12u as=0.1936p ps=1.76u w=0.44u l=0.28u
X451 a_3342_25131# a_3311_24625# VDD VDD pfet_03v3 ad=0.1936p pd=1.76u as=0.1496p ps=1.12u w=0.44u l=0.28u
X452 a_6452_7595# WL[6] WBL[7] VSS nfet_03v3 ad=0.1397p pd=1.22u as=0.1706p ps=1.7u w=0.32u l=0.28u
X453 a_4586_10883# a_4555_10377# VDD VDD pfet_03v3 ad=0.1936p pd=1.76u as=0.1496p ps=1.12u w=0.44u l=0.28u
X454 VSS a_5208_16363# a_5177_15857# VSS nfet_03v3 ad=0.1108p pd=1.1u as=0.139p ps=1.215u w=0.22u l=0.28u
X455 VSS a_5208_17459# a_5177_16953# VSS nfet_03v3 ad=0.1108p pd=1.1u as=0.139p ps=1.215u w=0.22u l=0.28u
X456 a_4586_2115# a_4555_1609# VDD VDD pfet_03v3 ad=0.1936p pd=1.76u as=0.1496p ps=1.12u w=0.44u l=0.28u
X457 a_3964_21843# a_3933_21337# VDD VDD pfet_03v3 ad=0.1936p pd=1.76u as=0.1496p ps=1.12u w=0.44u l=0.28u
X458 a_2720_10883# WL[9] WBL[1] VSS nfet_03v3 ad=0.1397p pd=1.22u as=0.1706p ps=1.7u w=0.32u l=0.28u
X459 a_2720_11979# WL[10] WBL[1] VSS nfet_03v3 ad=0.1397p pd=1.22u as=0.1706p ps=1.7u w=0.32u l=0.28u
X460 VSS a_2098_6499# a_2067_5993# VSS nfet_03v3 ad=0.1108p pd=1.1u as=0.139p ps=1.215u w=0.22u l=0.28u
X461 RBL[44] a_4555_5993# VSS VSS nfet_03v3 ad=0.1516p pd=1.64u as=0.1516p ps=1.64u w=0.22u l=0.28u
X462 a_2098_14171# a_2067_13665# VDD VDD pfet_03v3 ad=0.1936p pd=1.76u as=0.1496p ps=1.12u w=0.44u l=0.28u
X463 RBL[36] a_4555_4897# VSS VSS nfet_03v3 ad=0.1516p pd=1.64u as=0.1516p ps=1.64u w=0.22u l=0.28u
X464 RBL[18] a_3311_2705# VSS VSS nfet_03v3 ad=0.1516p pd=1.64u as=0.1516p ps=1.64u w=0.22u l=0.28u
X465 RBL[116] a_4586_16363# A[14] VSS nfet_03v3 ad=0.1516p pd=1.64u as=0.1516p ps=1.64u w=0.22u l=0.28u
X466 RBL[124] a_4586_17459# A[15] VSS nfet_03v3 ad=0.1516p pd=1.64u as=0.1516p ps=1.64u w=0.22u l=0.28u
X467 RBL[93] a_5208_13075# A[11] VSS nfet_03v3 ad=0.1516p pd=1.64u as=0.1516p ps=1.64u w=0.22u l=0.28u
X468 a_5799_25721# WL[23] WBLB[6] VSS nfet_03v3 ad=0.139p pd=1.215u as=0.2362p ps=2.03u w=0.32u l=0.28u
X469 a_5799_24625# WL[22] WBLB[6] VSS nfet_03v3 ad=0.139p pd=1.215u as=0.2362p ps=2.03u w=0.32u l=0.28u
X470 a_5208_10883# a_5177_10377# VDD VDD pfet_03v3 ad=0.1936p pd=1.76u as=0.1496p ps=1.12u w=0.44u l=0.28u
X471 VDD a_2098_1019# a_2067_513# VDD pfet_03v3 ad=0.1496p pd=1.12u as=0.1936p ps=1.76u w=0.44u l=0.28u
X472 a_5830_6499# WL[5] WBL[6] VSS nfet_03v3 ad=0.1397p pd=1.22u as=0.1706p ps=1.7u w=0.32u l=0.28u
X473 a_5830_5403# WL[4] WBL[6] VSS nfet_03v3 ad=0.1397p pd=1.22u as=0.1706p ps=1.7u w=0.32u l=0.28u
X474 RBL[18] a_3342_3211# A[2] VSS nfet_03v3 ad=0.1516p pd=1.64u as=0.1516p ps=1.64u w=0.22u l=0.28u
X475 RBL[90] a_3311_12569# VSS VSS nfet_03v3 ad=0.1516p pd=1.64u as=0.1516p ps=1.64u w=0.22u l=0.28u
X476 RBL[239] a_6452_32803# A[29] VSS nfet_03v3 ad=0.1516p pd=1.64u as=0.1516p ps=1.64u w=0.22u l=0.28u
X477 RBL[169] a_2689_23529# VSS VSS nfet_03v3 ad=0.1516p pd=1.64u as=0.1516p ps=1.64u w=0.22u l=0.28u
X478 a_3342_16363# WL[14] WBL[2] VSS nfet_03v3 ad=0.1397p pd=1.22u as=0.1706p ps=1.7u w=0.32u l=0.28u
X479 a_3342_17459# WL[15] WBL[2] VSS nfet_03v3 ad=0.1397p pd=1.22u as=0.1706p ps=1.7u w=0.32u l=0.28u
X480 RBL[27] a_3933_3801# VSS VSS nfet_03v3 ad=0.1516p pd=1.64u as=0.1516p ps=1.64u w=0.22u l=0.28u
X481 a_3342_32803# a_3311_32297# VDD VDD pfet_03v3 ad=0.1936p pd=1.76u as=0.1496p ps=1.12u w=0.44u l=0.28u
X482 a_3342_25131# a_3311_24625# VSS VSS nfet_03v3 ad=0.1397p pd=1.22u as=0.1108p ps=1.1u w=0.22u l=0.28u
X483 a_3342_24035# a_3311_23529# VSS VSS nfet_03v3 ad=0.1397p pd=1.22u as=0.1108p ps=1.1u w=0.22u l=0.28u
X484 a_3964_20747# a_3933_20241# VSS VSS nfet_03v3 ad=0.1397p pd=1.22u as=0.1108p ps=1.1u w=0.22u l=0.28u
X485 a_4586_7595# a_4555_7089# VSS VSS nfet_03v3 ad=0.1397p pd=1.22u as=0.1108p ps=1.1u w=0.22u l=0.28u
X486 RBL[134] a_5830_18555# A[16] VSS nfet_03v3 ad=0.1516p pd=1.64u as=0.1516p ps=1.64u w=0.22u l=0.28u
X487 a_6452_13075# WL[11] WBL[7] VSS nfet_03v3 ad=0.1397p pd=1.22u as=0.1706p ps=1.7u w=0.32u l=0.28u
X488 a_2098_13075# a_2067_12569# VSS VSS nfet_03v3 ad=0.1397p pd=1.22u as=0.1108p ps=1.1u w=0.22u l=0.28u
X489 a_2098_14171# a_2067_13665# VSS VSS nfet_03v3 ad=0.1397p pd=1.22u as=0.1108p ps=1.1u w=0.22u l=0.28u
X490 a_2720_18555# a_2689_18049# VDD VDD pfet_03v3 ad=0.1936p pd=1.76u as=0.1496p ps=1.12u w=0.44u l=0.28u
X491 a_5830_31707# a_5799_31201# VSS VSS nfet_03v3 ad=0.1397p pd=1.22u as=0.1108p ps=1.1u w=0.22u l=0.28u
X492 a_2720_17459# a_2689_16953# VDD VDD pfet_03v3 ad=0.1936p pd=1.76u as=0.1496p ps=1.12u w=0.44u l=0.28u
X493 VDD a_3964_29515# a_3933_29009# VDD pfet_03v3 ad=0.1496p pd=1.12u as=0.1936p ps=1.76u w=0.44u l=0.28u
X494 VDD a_3964_28419# a_3933_27913# VDD pfet_03v3 ad=0.1496p pd=1.12u as=0.1936p ps=1.76u w=0.44u l=0.28u
X495 VDD a_2720_1019# a_2689_513# VDD pfet_03v3 ad=0.1496p pd=1.12u as=0.1936p ps=1.76u w=0.44u l=0.28u
X496 RBL[232] a_2067_32297# VSS VSS nfet_03v3 ad=0.1516p pd=1.64u as=0.1516p ps=1.64u w=0.22u l=0.28u
X497 RBL[236] a_4555_32297# VSS VSS nfet_03v3 ad=0.1516p pd=1.64u as=0.1516p ps=1.64u w=0.22u l=0.28u
X498 a_2098_34995# WL[31] WBL[0] VSS nfet_03v3 ad=0.1397p pd=1.22u as=0.1706p ps=1.7u w=0.32u l=0.28u
X499 VSS a_5208_9787# a_5177_9281# VSS nfet_03v3 ad=0.1108p pd=1.1u as=0.139p ps=1.215u w=0.22u l=0.28u
X500 RBL[55] a_6421_7089# VSS VSS nfet_03v3 ad=0.1516p pd=1.64u as=0.1516p ps=1.64u w=0.22u l=0.28u
X501 a_4555_18049# WL[16] WBLB[4] VSS nfet_03v3 ad=0.139p pd=1.215u as=0.2362p ps=2.03u w=0.32u l=0.28u
X502 a_6452_33899# a_6421_33393# VSS VSS nfet_03v3 ad=0.1397p pd=1.22u as=0.1108p ps=1.1u w=0.22u l=0.28u
X503 a_6452_32803# a_6421_32297# VSS VSS nfet_03v3 ad=0.1397p pd=1.22u as=0.1108p ps=1.1u w=0.22u l=0.28u
X504 a_5208_31707# WL[28] WBL[5] VSS nfet_03v3 ad=0.1397p pd=1.22u as=0.1706p ps=1.7u w=0.32u l=0.28u
X505 RBL[110] a_5799_14761# A[13] VDD pfet_03v3 ad=0.2082p pd=1.84u as=0.2024p ps=1.8u w=0.44u l=0.28u
X506 RBL[118] a_5799_15857# A[14] VDD pfet_03v3 ad=0.2082p pd=1.84u as=0.2024p ps=1.8u w=0.44u l=0.28u
X507 VDD a_6452_4307# a_6421_3801# VDD pfet_03v3 ad=0.1496p pd=1.12u as=0.1936p ps=1.76u w=0.44u l=0.28u
X508 a_3342_24035# WL[21] WBL[2] VSS nfet_03v3 ad=0.1397p pd=1.22u as=0.1706p ps=1.7u w=0.32u l=0.28u
X509 RBL[38] a_5799_4897# A[4] VDD pfet_03v3 ad=0.2082p pd=1.84u as=0.2024p ps=1.8u w=0.44u l=0.28u
X510 RBL[30] a_5799_3801# A[3] VDD pfet_03v3 ad=0.2082p pd=1.84u as=0.2024p ps=1.8u w=0.44u l=0.28u
X511 a_2067_19145# WL[17] WBLB[0] VSS nfet_03v3 ad=0.139p pd=1.215u as=0.2362p ps=2.03u w=0.32u l=0.28u
X512 a_5208_2115# a_5177_1609# VDD VDD pfet_03v3 ad=0.1936p pd=1.76u as=0.1496p ps=1.12u w=0.44u l=0.28u
X513 RBL[55] a_6452_7595# A[6] VSS nfet_03v3 ad=0.1516p pd=1.64u as=0.1516p ps=1.64u w=0.22u l=0.28u
X514 RBL[200] a_2098_28419# A[25] VSS nfet_03v3 ad=0.1516p pd=1.64u as=0.1516p ps=1.64u w=0.22u l=0.28u
X515 RBL[192] a_2098_27323# A[24] VSS nfet_03v3 ad=0.1516p pd=1.64u as=0.1516p ps=1.64u w=0.22u l=0.28u
X516 a_2720_1019# a_2689_513# VDD VDD pfet_03v3 ad=0.1936p pd=1.76u as=0.1496p ps=1.12u w=0.44u l=0.28u
X517 a_3342_10883# a_3311_10377# VDD VDD pfet_03v3 ad=0.1936p pd=1.76u as=0.1496p ps=1.12u w=0.44u l=0.28u
X518 RBL[127] a_6421_16953# A[15] VDD pfet_03v3 ad=0.2082p pd=1.84u as=0.2024p ps=1.8u w=0.44u l=0.28u
X519 VDD a_5208_17459# a_5177_16953# VDD pfet_03v3 ad=0.1496p pd=1.12u as=0.1936p ps=1.76u w=0.44u l=0.28u
X520 VDD a_5208_18555# a_5177_18049# VDD pfet_03v3 ad=0.1496p pd=1.12u as=0.1936p ps=1.76u w=0.44u l=0.28u
X521 a_6421_33393# WL[30] WBLB[7] VSS nfet_03v3 ad=0.139p pd=1.215u as=0.2362p ps=2.03u w=0.32u l=0.28u
X522 a_6421_32297# WL[29] WBLB[7] VSS nfet_03v3 ad=0.139p pd=1.215u as=0.2362p ps=2.03u w=0.32u l=0.28u
X523 a_4555_25721# WL[23] WBLB[4] VSS nfet_03v3 ad=0.139p pd=1.215u as=0.2362p ps=2.03u w=0.32u l=0.28u
X524 a_4555_24625# WL[22] WBLB[4] VSS nfet_03v3 ad=0.139p pd=1.215u as=0.2362p ps=2.03u w=0.32u l=0.28u
X525 RBL[24] a_2098_4307# A[3] VSS nfet_03v3 ad=0.1516p pd=1.64u as=0.1516p ps=1.64u w=0.22u l=0.28u
X526 RBL[24] a_2067_3801# VSS VSS nfet_03v3 ad=0.1516p pd=1.64u as=0.1516p ps=1.64u w=0.22u l=0.28u
X527 RBL[236] a_4586_32803# A[29] VSS nfet_03v3 ad=0.1516p pd=1.64u as=0.1516p ps=1.64u w=0.22u l=0.28u
X528 RBL[217] a_2689_30105# A[27] VDD pfet_03v3 ad=0.2082p pd=1.84u as=0.2024p ps=1.8u w=0.44u l=0.28u
X529 a_5830_8691# a_5799_8185# VDD VDD pfet_03v3 ad=0.1936p pd=1.76u as=0.1496p ps=1.12u w=0.44u l=0.28u
X530 a_5830_9787# a_5799_9281# VDD VDD pfet_03v3 ad=0.1936p pd=1.76u as=0.1496p ps=1.12u w=0.44u l=0.28u
X531 a_2098_13075# WL[11] WBL[0] VSS nfet_03v3 ad=0.1397p pd=1.22u as=0.1706p ps=1.7u w=0.32u l=0.28u
X532 a_2067_5993# WL[5] WBLB[0] VSS nfet_03v3 ad=0.139p pd=1.215u as=0.2362p ps=2.03u w=0.32u l=0.28u
X533 a_2067_4897# WL[4] WBLB[0] VSS nfet_03v3 ad=0.139p pd=1.215u as=0.2362p ps=2.03u w=0.32u l=0.28u
X534 a_6452_20747# a_6421_20241# VDD VDD pfet_03v3 ad=0.1936p pd=1.76u as=0.1496p ps=1.12u w=0.44u l=0.28u
X535 RBL[131] a_3964_18555# A[16] VSS nfet_03v3 ad=0.1516p pd=1.64u as=0.1516p ps=1.64u w=0.22u l=0.28u
X536 RBL[210] a_3342_29515# A[26] VSS nfet_03v3 ad=0.1516p pd=1.64u as=0.1516p ps=1.64u w=0.22u l=0.28u
X537 a_5208_7595# a_5177_7089# VSS VSS nfet_03v3 ad=0.1397p pd=1.22u as=0.1108p ps=1.1u w=0.22u l=0.28u
X538 VDD a_2098_29515# a_2067_29009# VDD pfet_03v3 ad=0.1496p pd=1.12u as=0.1936p ps=1.76u w=0.44u l=0.28u
X539 VDD a_2098_28419# a_2067_27913# VDD pfet_03v3 ad=0.1496p pd=1.12u as=0.1936p ps=1.76u w=0.44u l=0.28u
X540 VDD a_4586_4307# a_4555_3801# VDD pfet_03v3 ad=0.1496p pd=1.12u as=0.1936p ps=1.76u w=0.44u l=0.28u
X541 VDD a_6452_19651# a_6421_19145# VDD pfet_03v3 ad=0.1496p pd=1.12u as=0.1936p ps=1.76u w=0.44u l=0.28u
X542 RBL[248] a_2098_34995# A[31] VSS nfet_03v3 ad=0.1516p pd=1.64u as=0.1516p ps=1.64u w=0.22u l=0.28u
X543 RBL[91] a_3933_12569# A[11] VDD pfet_03v3 ad=0.2082p pd=1.84u as=0.2024p ps=1.8u w=0.44u l=0.28u
X544 VSS a_2720_3211# a_2689_2705# VSS nfet_03v3 ad=0.1108p pd=1.1u as=0.139p ps=1.215u w=0.22u l=0.28u
X545 VSS a_2720_2115# a_2689_1609# VSS nfet_03v3 ad=0.1108p pd=1.1u as=0.139p ps=1.215u w=0.22u l=0.28u
X546 RBL[191] a_6452_26227# A[23] VSS nfet_03v3 ad=0.1516p pd=1.64u as=0.1516p ps=1.64u w=0.22u l=0.28u
X547 RBL[183] a_6452_25131# A[22] VSS nfet_03v3 ad=0.1516p pd=1.64u as=0.1516p ps=1.64u w=0.22u l=0.28u
X548 a_3342_2115# a_3311_1609# VDD VDD pfet_03v3 ad=0.1936p pd=1.76u as=0.1496p ps=1.12u w=0.44u l=0.28u
X549 VSS a_3342_9787# a_3311_9281# VSS nfet_03v3 ad=0.1108p pd=1.1u as=0.139p ps=1.215u w=0.22u l=0.28u
X550 RBL[52] a_4586_7595# A[6] VSS nfet_03v3 ad=0.1516p pd=1.64u as=0.1516p ps=1.64u w=0.22u l=0.28u
X551 RBL[174] a_5799_23529# A[21] VDD pfet_03v3 ad=0.2082p pd=1.84u as=0.2024p ps=1.8u w=0.44u l=0.28u
X552 VSS a_6452_4307# a_6421_3801# VSS nfet_03v3 ad=0.1108p pd=1.1u as=0.139p ps=1.215u w=0.22u l=0.28u
X553 a_4586_33899# a_4555_33393# VSS VSS nfet_03v3 ad=0.1397p pd=1.22u as=0.1108p ps=1.1u w=0.22u l=0.28u
X554 a_4586_32803# a_4555_32297# VSS VSS nfet_03v3 ad=0.1397p pd=1.22u as=0.1108p ps=1.1u w=0.22u l=0.28u
X555 a_2098_15267# a_2067_14761# VDD VDD pfet_03v3 ad=0.1936p pd=1.76u as=0.1496p ps=1.12u w=0.44u l=0.28u
X556 a_2689_18049# WL[16] WBLB[1] VSS nfet_03v3 ad=0.139p pd=1.215u as=0.2362p ps=2.03u w=0.32u l=0.28u
X557 a_3311_13665# WL[12] WBLB[2] VSS nfet_03v3 ad=0.139p pd=1.215u as=0.2362p ps=2.03u w=0.32u l=0.28u
X558 a_3311_14761# WL[13] WBLB[2] VSS nfet_03v3 ad=0.139p pd=1.215u as=0.2362p ps=2.03u w=0.32u l=0.28u
X559 RBL[184] a_2067_25721# VSS VSS nfet_03v3 ad=0.1516p pd=1.64u as=0.1516p ps=1.64u w=0.22u l=0.28u
X560 RBL[176] a_2067_24625# VSS VSS nfet_03v3 ad=0.1516p pd=1.64u as=0.1516p ps=1.64u w=0.22u l=0.28u
X561 a_5799_8185# WL[7] WBLB[6] VSS nfet_03v3 ad=0.139p pd=1.215u as=0.2362p ps=2.03u w=0.32u l=0.28u
X562 a_5799_9281# WL[8] WBLB[6] VSS nfet_03v3 ad=0.139p pd=1.215u as=0.2362p ps=2.03u w=0.32u l=0.28u
X563 a_6452_3211# a_6421_2705# VSS VSS nfet_03v3 ad=0.1397p pd=1.22u as=0.1108p ps=1.1u w=0.22u l=0.28u
X564 a_6452_2115# a_6421_1609# VSS VSS nfet_03v3 ad=0.1397p pd=1.22u as=0.1108p ps=1.1u w=0.22u l=0.28u
X565 a_2720_34995# a_2689_34489# VDD VDD pfet_03v3 ad=0.1936p pd=1.76u as=0.1496p ps=1.12u w=0.44u l=0.28u
X566 a_2720_26227# a_2689_25721# VSS VSS nfet_03v3 ad=0.1397p pd=1.22u as=0.1108p ps=1.1u w=0.22u l=0.28u
X567 a_2098_6499# WL[5] WBL[0] VSS nfet_03v3 ad=0.1397p pd=1.22u as=0.1706p ps=1.7u w=0.32u l=0.28u
X568 a_2720_33899# a_2689_33393# VDD VDD pfet_03v3 ad=0.1936p pd=1.76u as=0.1496p ps=1.12u w=0.44u l=0.28u
X569 a_2098_5403# WL[4] WBL[0] VSS nfet_03v3 ad=0.1397p pd=1.22u as=0.1706p ps=1.7u w=0.32u l=0.28u
X570 a_6421_10377# WL[9] WBLB[7] VSS nfet_03v3 ad=0.139p pd=1.215u as=0.2362p ps=2.03u w=0.32u l=0.28u
X571 a_6421_11473# WL[10] WBLB[7] VSS nfet_03v3 ad=0.139p pd=1.215u as=0.2362p ps=2.03u w=0.32u l=0.28u
X572 RBL[188] a_4555_25721# VSS VSS nfet_03v3 ad=0.1516p pd=1.64u as=0.1516p ps=1.64u w=0.22u l=0.28u
X573 RBL[180] a_4555_24625# VSS VSS nfet_03v3 ad=0.1516p pd=1.64u as=0.1516p ps=1.64u w=0.22u l=0.28u
X574 a_5830_8691# a_5799_8185# VSS VSS nfet_03v3 ad=0.1397p pd=1.22u as=0.1108p ps=1.1u w=0.22u l=0.28u
X575 RBL[157] a_5177_21337# VSS VSS nfet_03v3 ad=0.1516p pd=1.64u as=0.1516p ps=1.64u w=0.22u l=0.28u
X576 RBL[165] a_5177_22433# VSS VSS nfet_03v3 ad=0.1516p pd=1.64u as=0.1516p ps=1.64u w=0.22u l=0.28u
X577 a_5208_33899# a_5177_33393# VSS VSS nfet_03v3 ad=0.1397p pd=1.22u as=0.1108p ps=1.1u w=0.22u l=0.28u
X578 a_5208_32803# a_5177_32297# VSS VSS nfet_03v3 ad=0.1397p pd=1.22u as=0.1108p ps=1.1u w=0.22u l=0.28u
X579 a_3964_31707# WL[28] WBL[3] VSS nfet_03v3 ad=0.1397p pd=1.22u as=0.1706p ps=1.7u w=0.32u l=0.28u
X580 VDD a_6452_27323# a_6421_26817# VDD pfet_03v3 ad=0.1496p pd=1.12u as=0.1936p ps=1.76u w=0.44u l=0.28u
X581 VSS a_6452_18555# a_6421_18049# VSS nfet_03v3 ad=0.1108p pd=1.1u as=0.139p ps=1.215u w=0.22u l=0.28u
X582 VSS a_6452_19651# a_6421_19145# VSS nfet_03v3 ad=0.1108p pd=1.1u as=0.139p ps=1.215u w=0.22u l=0.28u
X583 RBL[124] a_4555_16953# A[15] VDD pfet_03v3 ad=0.2082p pd=1.84u as=0.2024p ps=1.8u w=0.44u l=0.28u
X584 RBL[203] a_3933_27913# A[25] VDD pfet_03v3 ad=0.2082p pd=1.84u as=0.2024p ps=1.8u w=0.44u l=0.28u
X585 RBL[247] a_6452_33899# A[30] VSS nfet_03v3 ad=0.1516p pd=1.64u as=0.1516p ps=1.64u w=0.22u l=0.28u
X586 a_3342_7595# a_3311_7089# VSS VSS nfet_03v3 ad=0.1397p pd=1.22u as=0.1108p ps=1.1u w=0.22u l=0.28u
X587 a_4586_33899# WL[30] WBL[4] VSS nfet_03v3 ad=0.1397p pd=1.22u as=0.1706p ps=1.7u w=0.32u l=0.28u
X588 a_4586_32803# WL[29] WBL[4] VSS nfet_03v3 ad=0.1397p pd=1.22u as=0.1706p ps=1.7u w=0.32u l=0.28u
X589 RBL[88] a_2098_13075# A[11] VSS nfet_03v3 ad=0.1516p pd=1.64u as=0.1516p ps=1.64u w=0.22u l=0.28u
X590 a_2689_25721# WL[23] WBLB[1] VSS nfet_03v3 ad=0.139p pd=1.215u as=0.2362p ps=2.03u w=0.32u l=0.28u
X591 a_2689_24625# WL[22] WBLB[1] VSS nfet_03v3 ad=0.139p pd=1.215u as=0.2362p ps=2.03u w=0.32u l=0.28u
X592 a_3311_22433# WL[20] WBLB[2] VSS nfet_03v3 ad=0.139p pd=1.215u as=0.2362p ps=2.03u w=0.32u l=0.28u
X593 VSS a_4586_4307# a_4555_3801# VSS nfet_03v3 ad=0.1108p pd=1.1u as=0.139p ps=1.215u w=0.22u l=0.28u
X594 RBL[125] a_5177_16953# A[15] VDD pfet_03v3 ad=0.2082p pd=1.84u as=0.2024p ps=1.8u w=0.44u l=0.28u
X595 RBL[240] a_2067_33393# VSS VSS nfet_03v3 ad=0.1516p pd=1.64u as=0.1516p ps=1.64u w=0.22u l=0.28u
X596 VSS a_2720_31707# a_2689_31201# VSS nfet_03v3 ad=0.1108p pd=1.1u as=0.139p ps=1.215u w=0.22u l=0.28u
X597 a_5177_33393# WL[30] WBLB[5] VSS nfet_03v3 ad=0.139p pd=1.215u as=0.2362p ps=2.03u w=0.32u l=0.28u
X598 a_5177_32297# WL[29] WBLB[5] VSS nfet_03v3 ad=0.139p pd=1.215u as=0.2362p ps=2.03u w=0.32u l=0.28u
X599 RBL[244] a_4555_33393# VSS VSS nfet_03v3 ad=0.1516p pd=1.64u as=0.1516p ps=1.64u w=0.22u l=0.28u
X600 VSS a_5208_26227# a_5177_25721# VSS nfet_03v3 ad=0.1108p pd=1.1u as=0.139p ps=1.215u w=0.22u l=0.28u
X601 VDD a_5208_34995# a_5177_34489# VDD pfet_03v3 ad=0.1496p pd=1.12u as=0.1936p ps=1.76u w=0.44u l=0.28u
X602 VDD a_5208_33899# a_5177_33393# VDD pfet_03v3 ad=0.1496p pd=1.12u as=0.1936p ps=1.76u w=0.44u l=0.28u
X603 a_4586_3211# a_4555_2705# VSS VSS nfet_03v3 ad=0.1397p pd=1.22u as=0.1108p ps=1.1u w=0.22u l=0.28u
X604 a_4586_2115# a_4555_1609# VSS VSS nfet_03v3 ad=0.1397p pd=1.22u as=0.1108p ps=1.1u w=0.22u l=0.28u
X605 a_4586_20747# a_4555_20241# VDD VDD pfet_03v3 ad=0.1936p pd=1.76u as=0.1496p ps=1.12u w=0.44u l=0.28u
X606 RBL[32] a_2067_4897# A[4] VDD pfet_03v3 ad=0.2082p pd=1.84u as=0.2024p ps=1.8u w=0.44u l=0.28u
X607 RBL[24] a_2067_3801# A[3] VDD pfet_03v3 ad=0.2082p pd=1.84u as=0.2024p ps=1.8u w=0.44u l=0.28u
X608 a_2720_11979# a_2689_11473# VDD VDD pfet_03v3 ad=0.1936p pd=1.76u as=0.1496p ps=1.12u w=0.44u l=0.28u
X609 a_2720_13075# a_2689_12569# VDD VDD pfet_03v3 ad=0.1936p pd=1.76u as=0.1496p ps=1.12u w=0.44u l=0.28u
X610 a_2720_20747# WL[18] WBL[1] VSS nfet_03v3 ad=0.1397p pd=1.22u as=0.1706p ps=1.7u w=0.32u l=0.28u
X611 a_2098_24035# a_2067_23529# VDD VDD pfet_03v3 ad=0.1936p pd=1.76u as=0.1496p ps=1.12u w=0.44u l=0.28u
X612 VSS a_3964_15267# a_3933_14761# VSS nfet_03v3 ad=0.1108p pd=1.1u as=0.139p ps=1.215u w=0.22u l=0.28u
X613 a_2098_22939# a_2067_22433# VDD VDD pfet_03v3 ad=0.1936p pd=1.76u as=0.1496p ps=1.12u w=0.44u l=0.28u
X614 VDD a_4586_19651# a_4555_19145# VDD pfet_03v3 ad=0.1496p pd=1.12u as=0.1936p ps=1.76u w=0.44u l=0.28u
X615 RBL[49] a_2720_7595# A[6] VSS nfet_03v3 ad=0.1516p pd=1.64u as=0.1516p ps=1.64u w=0.22u l=0.28u
X616 RBL[188] a_4586_26227# A[23] VSS nfet_03v3 ad=0.1516p pd=1.64u as=0.1516p ps=1.64u w=0.22u l=0.28u
X617 RBL[180] a_4586_25131# A[22] VSS nfet_03v3 ad=0.1516p pd=1.64u as=0.1516p ps=1.64u w=0.22u l=0.28u
X618 VDD a_3342_1019# a_3311_513# VDD pfet_03v3 ad=0.1496p pd=1.12u as=0.1936p ps=1.76u w=0.44u l=0.28u
X619 RBL[157] a_5208_21843# A[19] VSS nfet_03v3 ad=0.1516p pd=1.64u as=0.1516p ps=1.64u w=0.22u l=0.28u
X620 RBL[165] a_5208_22939# A[20] VSS nfet_03v3 ad=0.1516p pd=1.64u as=0.1516p ps=1.64u w=0.22u l=0.28u
X621 a_5799_34489# WL[31] WBLB[6] VSS nfet_03v3 ad=0.139p pd=1.215u as=0.2362p ps=2.03u w=0.32u l=0.28u
X622 a_5208_20747# a_5177_20241# VDD VDD pfet_03v3 ad=0.1936p pd=1.76u as=0.1496p ps=1.12u w=0.44u l=0.28u
X623 RBL[98] a_3342_14171# A[12] VSS nfet_03v3 ad=0.1516p pd=1.64u as=0.1516p ps=1.64u w=0.22u l=0.28u
X624 RBL[106] a_3342_15267# A[13] VSS nfet_03v3 ad=0.1516p pd=1.64u as=0.1516p ps=1.64u w=0.22u l=0.28u
X625 RBL[221] a_5177_30105# VSS VSS nfet_03v3 ad=0.1516p pd=1.64u as=0.1516p ps=1.64u w=0.22u l=0.28u
X626 a_3933_27913# WL[25] WBLB[3] VSS nfet_03v3 ad=0.139p pd=1.215u as=0.2362p ps=2.03u w=0.32u l=0.28u
X627 a_3933_26817# WL[24] WBLB[3] VSS nfet_03v3 ad=0.139p pd=1.215u as=0.2362p ps=2.03u w=0.32u l=0.28u
X628 RBL[6] a_5799_513# A[0] VDD pfet_03v3 ad=0.2082p pd=1.84u as=0.2024p ps=1.8u w=0.44u l=0.28u
X629 RBL[87] a_6452_11979# A[10] VSS nfet_03v3 ad=0.1516p pd=1.64u as=0.1516p ps=1.64u w=0.22u l=0.28u
X630 RBL[79] a_6452_10883# A[9] VSS nfet_03v3 ad=0.1516p pd=1.64u as=0.1516p ps=1.64u w=0.22u l=0.28u
X631 VSS a_6452_28419# a_6421_27913# VSS nfet_03v3 ad=0.1108p pd=1.1u as=0.139p ps=1.215u w=0.22u l=0.28u
X632 VSS a_6452_27323# a_6421_26817# VSS nfet_03v3 ad=0.1108p pd=1.1u as=0.139p ps=1.215u w=0.22u l=0.28u
X633 RBL[78] a_5799_10377# A[9] VDD pfet_03v3 ad=0.2082p pd=1.84u as=0.2024p ps=1.8u w=0.44u l=0.28u
X634 RBL[154] a_3311_21337# VSS VSS nfet_03v3 ad=0.1516p pd=1.64u as=0.1516p ps=1.64u w=0.22u l=0.28u
X635 RBL[162] a_3311_22433# VSS VSS nfet_03v3 ad=0.1516p pd=1.64u as=0.1516p ps=1.64u w=0.22u l=0.28u
X636 a_2098_8691# a_2067_8185# VDD VDD pfet_03v3 ad=0.1936p pd=1.76u as=0.1496p ps=1.12u w=0.44u l=0.28u
X637 a_2098_9787# a_2067_9281# VDD VDD pfet_03v3 ad=0.1936p pd=1.76u as=0.1496p ps=1.12u w=0.44u l=0.28u
X638 a_4586_11979# WL[10] WBL[4] VSS nfet_03v3 ad=0.1397p pd=1.22u as=0.1706p ps=1.7u w=0.32u l=0.28u
X639 a_3342_33899# a_3311_33393# VSS VSS nfet_03v3 ad=0.1397p pd=1.22u as=0.1108p ps=1.1u w=0.22u l=0.28u
X640 a_3342_32803# a_3311_32297# VSS VSS nfet_03v3 ad=0.1397p pd=1.22u as=0.1108p ps=1.1u w=0.22u l=0.28u
X641 a_4586_10883# WL[9] WBL[4] VSS nfet_03v3 ad=0.1397p pd=1.22u as=0.1706p ps=1.7u w=0.32u l=0.28u
X642 a_2067_13665# WL[12] WBLB[0] VSS nfet_03v3 ad=0.139p pd=1.215u as=0.2362p ps=2.03u w=0.32u l=0.28u
X643 a_2067_14761# WL[13] WBLB[0] VSS nfet_03v3 ad=0.139p pd=1.215u as=0.2362p ps=2.03u w=0.32u l=0.28u
X644 a_3964_30611# a_3933_30105# VSS VSS nfet_03v3 ad=0.1397p pd=1.22u as=0.1108p ps=1.1u w=0.22u l=0.28u
X645 RBL[72] a_2067_10377# VSS VSS nfet_03v3 ad=0.1516p pd=1.64u as=0.1516p ps=1.64u w=0.22u l=0.28u
X646 RBL[80] a_2067_11473# VSS VSS nfet_03v3 ad=0.1516p pd=1.64u as=0.1516p ps=1.64u w=0.22u l=0.28u
X647 RBL[206] a_5830_28419# A[25] VSS nfet_03v3 ad=0.1516p pd=1.64u as=0.1516p ps=1.64u w=0.22u l=0.28u
X648 RBL[198] a_5830_27323# A[24] VSS nfet_03v3 ad=0.1516p pd=1.64u as=0.1516p ps=1.64u w=0.22u l=0.28u
X649 a_2720_10883# a_2689_10377# VSS VSS nfet_03v3 ad=0.1397p pd=1.22u as=0.1108p ps=1.1u w=0.22u l=0.28u
X650 a_2720_11979# a_2689_11473# VSS VSS nfet_03v3 ad=0.1397p pd=1.22u as=0.1108p ps=1.1u w=0.22u l=0.28u
X651 a_6452_21843# WL[19] WBL[7] VSS nfet_03v3 ad=0.1397p pd=1.22u as=0.1706p ps=1.7u w=0.32u l=0.28u
X652 a_2098_21843# a_2067_21337# VSS VSS nfet_03v3 ad=0.1397p pd=1.22u as=0.1108p ps=1.1u w=0.22u l=0.28u
X653 a_2098_22939# a_2067_22433# VSS VSS nfet_03v3 ad=0.1397p pd=1.22u as=0.1108p ps=1.1u w=0.22u l=0.28u
X654 a_2098_31707# a_2067_31201# VDD VDD pfet_03v3 ad=0.1936p pd=1.76u as=0.1496p ps=1.12u w=0.44u l=0.28u
X655 a_2098_30611# a_2067_30105# VDD VDD pfet_03v3 ad=0.1936p pd=1.76u as=0.1496p ps=1.12u w=0.44u l=0.28u
X656 VSS a_4586_18555# a_4555_18049# VSS nfet_03v3 ad=0.1108p pd=1.1u as=0.139p ps=1.215u w=0.22u l=0.28u
X657 VSS a_4586_19651# a_4555_19145# VSS nfet_03v3 ad=0.1108p pd=1.1u as=0.139p ps=1.215u w=0.22u l=0.28u
X658 VSS a_3964_29515# a_3933_29009# VSS nfet_03v3 ad=0.1108p pd=1.1u as=0.139p ps=1.215u w=0.22u l=0.28u
X659 VDD a_4586_27323# a_4555_26817# VDD pfet_03v3 ad=0.1496p pd=1.12u as=0.1936p ps=1.76u w=0.44u l=0.28u
X660 a_3933_1609# WL[1] WBLB[3] VSS nfet_03v3 ad=0.139p pd=1.215u as=0.2362p ps=2.03u w=0.32u l=0.28u
X661 a_5177_10377# WL[9] WBLB[5] VSS nfet_03v3 ad=0.139p pd=1.215u as=0.2362p ps=2.03u w=0.32u l=0.28u
X662 a_5177_11473# WL[10] WBLB[5] VSS nfet_03v3 ad=0.139p pd=1.215u as=0.2362p ps=2.03u w=0.32u l=0.28u
X663 RBL[76] a_4555_10377# VSS VSS nfet_03v3 ad=0.1516p pd=1.64u as=0.1516p ps=1.64u w=0.22u l=0.28u
X664 RBL[84] a_4555_11473# VSS VSS nfet_03v3 ad=0.1516p pd=1.64u as=0.1516p ps=1.64u w=0.22u l=0.28u
X665 RBL[244] a_4586_33899# A[30] VSS nfet_03v3 ad=0.1516p pd=1.64u as=0.1516p ps=1.64u w=0.22u l=0.28u
X666 RBL[87] a_6421_11473# A[10] VDD pfet_03v3 ad=0.2082p pd=1.84u as=0.2024p ps=1.8u w=0.44u l=0.28u
X667 VDD a_5208_11979# a_5177_11473# VDD pfet_03v3 ad=0.1496p pd=1.12u as=0.1936p ps=1.76u w=0.44u l=0.28u
X668 VDD a_5208_13075# a_5177_12569# VDD pfet_03v3 ad=0.1496p pd=1.12u as=0.1936p ps=1.76u w=0.44u l=0.28u
X669 RBL[43] a_3933_5993# A[5] VDD pfet_03v3 ad=0.2082p pd=1.84u as=0.2024p ps=1.8u w=0.44u l=0.28u
X670 RBL[122] a_3311_16953# A[15] VDD pfet_03v3 ad=0.2082p pd=1.84u as=0.2024p ps=1.8u w=0.44u l=0.28u
X671 a_5799_12569# WL[11] WBLB[6] VSS nfet_03v3 ad=0.139p pd=1.215u as=0.2362p ps=2.03u w=0.32u l=0.28u
X672 RBL[99] a_3933_13665# A[12] VDD pfet_03v3 ad=0.2082p pd=1.84u as=0.2024p ps=1.8u w=0.44u l=0.28u
X673 a_5830_3211# a_5799_2705# VDD VDD pfet_03v3 ad=0.1936p pd=1.76u as=0.1496p ps=1.12u w=0.44u l=0.28u
X674 RBL[221] a_5208_30611# A[27] VSS nfet_03v3 ad=0.1516p pd=1.64u as=0.1516p ps=1.64u w=0.22u l=0.28u
X675 a_2720_30611# WL[27] WBL[1] VSS nfet_03v3 ad=0.1397p pd=1.22u as=0.1706p ps=1.7u w=0.32u l=0.28u
X676 RBL[49] a_2689_7089# A[6] VDD pfet_03v3 ad=0.2082p pd=1.84u as=0.2024p ps=1.8u w=0.44u l=0.28u
X677 RBL[57] a_2689_8185# A[7] VDD pfet_03v3 ad=0.2082p pd=1.84u as=0.2024p ps=1.8u w=0.44u l=0.28u
X678 a_3342_33899# WL[30] WBL[2] VSS nfet_03v3 ad=0.1397p pd=1.22u as=0.1706p ps=1.7u w=0.32u l=0.28u
X679 RBL[182] a_5799_24625# A[22] VDD pfet_03v3 ad=0.2082p pd=1.84u as=0.2024p ps=1.8u w=0.44u l=0.28u
X680 a_2098_8691# a_2067_8185# VSS VSS nfet_03v3 ad=0.1397p pd=1.22u as=0.1108p ps=1.1u w=0.22u l=0.28u
X681 a_3342_32803# WL[29] WBL[2] VSS nfet_03v3 ad=0.1397p pd=1.22u as=0.1706p ps=1.7u w=0.32u l=0.28u
X682 a_4555_8185# WL[7] WBLB[4] VSS nfet_03v3 ad=0.139p pd=1.215u as=0.2362p ps=2.03u w=0.32u l=0.28u
X683 a_4555_9281# WL[8] WBLB[4] VSS nfet_03v3 ad=0.139p pd=1.215u as=0.2362p ps=2.03u w=0.32u l=0.28u
X684 a_2067_22433# WL[20] WBLB[0] VSS nfet_03v3 ad=0.139p pd=1.215u as=0.2362p ps=2.03u w=0.32u l=0.28u
X685 a_5208_3211# a_5177_2705# VSS VSS nfet_03v3 ad=0.1397p pd=1.22u as=0.1108p ps=1.1u w=0.22u l=0.28u
X686 a_5208_2115# a_5177_1609# VSS VSS nfet_03v3 ad=0.1397p pd=1.22u as=0.1108p ps=1.1u w=0.22u l=0.28u
X687 RBL[71] a_6421_9281# A[8] VDD pfet_03v3 ad=0.2082p pd=1.84u as=0.2024p ps=1.8u w=0.44u l=0.28u
X688 a_6421_513# WL[0] WBLB[7] VSS nfet_03v3 ad=0.139p pd=1.215u as=0.2362p ps=2.03u w=0.32u l=0.28u
X689 VSS a_2098_15267# a_2067_14761# VSS nfet_03v3 ad=0.1108p pd=1.1u as=0.139p ps=1.215u w=0.22u l=0.28u
X690 a_5830_28419# WL[25] WBL[6] VSS nfet_03v3 ad=0.1397p pd=1.22u as=0.1706p ps=1.7u w=0.32u l=0.28u
X691 a_5830_27323# WL[24] WBL[6] VSS nfet_03v3 ad=0.1397p pd=1.22u as=0.1706p ps=1.7u w=0.32u l=0.28u
X692 VDD a_5830_6499# a_5799_5993# VDD pfet_03v3 ad=0.1496p pd=1.12u as=0.1936p ps=1.76u w=0.44u l=0.28u
X693 VDD a_5830_7595# a_5799_7089# VDD pfet_03v3 ad=0.1496p pd=1.12u as=0.1936p ps=1.76u w=0.44u l=0.28u
X694 RBL[254] a_5830_34995# A[31] VSS nfet_03v3 ad=0.1516p pd=1.64u as=0.1516p ps=1.64u w=0.22u l=0.28u
X695 VDD a_6452_14171# a_6421_13665# VDD pfet_03v3 ad=0.1496p pd=1.12u as=0.1936p ps=1.76u w=0.44u l=0.28u
X696 RBL[151] a_6452_20747# A[18] VSS nfet_03v3 ad=0.1516p pd=1.64u as=0.1516p ps=1.64u w=0.22u l=0.28u
X697 a_6452_2115# WL[1] WBL[7] VSS nfet_03v3 ad=0.1397p pd=1.22u as=0.1706p ps=1.7u w=0.32u l=0.28u
X698 VSS a_5208_10883# a_5177_10377# VSS nfet_03v3 ad=0.1108p pd=1.1u as=0.139p ps=1.215u w=0.22u l=0.28u
X699 VSS a_5208_11979# a_5177_11473# VSS nfet_03v3 ad=0.1108p pd=1.1u as=0.139p ps=1.215u w=0.22u l=0.28u
X700 a_3342_20747# a_3311_20241# VDD VDD pfet_03v3 ad=0.1936p pd=1.76u as=0.1496p ps=1.12u w=0.44u l=0.28u
X701 RBL[199] a_6421_26817# A[24] VDD pfet_03v3 ad=0.2082p pd=1.84u as=0.2024p ps=1.8u w=0.44u l=0.28u
X702 RBL[191] a_6421_25721# A[23] VDD pfet_03v3 ad=0.2082p pd=1.84u as=0.2024p ps=1.8u w=0.44u l=0.28u
X703 RBL[218] a_3311_30105# VSS VSS nfet_03v3 ad=0.1516p pd=1.64u as=0.1516p ps=1.64u w=0.22u l=0.28u
X704 RBL[41] a_2689_5993# VSS VSS nfet_03v3 ad=0.1516p pd=1.64u as=0.1516p ps=1.64u w=0.22u l=0.28u
X705 RBL[33] a_2689_4897# VSS VSS nfet_03v3 ad=0.1516p pd=1.64u as=0.1516p ps=1.64u w=0.22u l=0.28u
X706 VDD a_3964_16363# a_3933_15857# VDD pfet_03v3 ad=0.1496p pd=1.12u as=0.1936p ps=1.76u w=0.44u l=0.28u
X707 a_5799_3801# WL[3] WBLB[6] VSS nfet_03v3 ad=0.139p pd=1.215u as=0.2362p ps=2.03u w=0.32u l=0.28u
X708 a_5799_2705# WL[2] WBLB[6] VSS nfet_03v3 ad=0.139p pd=1.215u as=0.2362p ps=2.03u w=0.32u l=0.28u
X709 RBL[76] a_4586_10883# A[9] VSS nfet_03v3 ad=0.1516p pd=1.64u as=0.1516p ps=1.64u w=0.22u l=0.28u
X710 RBL[84] a_4586_11979# A[10] VSS nfet_03v3 ad=0.1516p pd=1.64u as=0.1516p ps=1.64u w=0.22u l=0.28u
X711 RBL[144] a_2067_20241# VSS VSS nfet_03v3 ad=0.1516p pd=1.64u as=0.1516p ps=1.64u w=0.22u l=0.28u
X712 a_4555_34489# WL[31] WBLB[4] VSS nfet_03v3 ad=0.139p pd=1.215u as=0.2362p ps=2.03u w=0.32u l=0.28u
X713 VSS a_4586_28419# a_4555_27913# VSS nfet_03v3 ad=0.1108p pd=1.1u as=0.139p ps=1.215u w=0.22u l=0.28u
X714 VSS a_4586_27323# a_4555_26817# VSS nfet_03v3 ad=0.1108p pd=1.1u as=0.139p ps=1.215u w=0.22u l=0.28u
X715 a_5830_29515# a_5799_29009# VDD VDD pfet_03v3 ad=0.1936p pd=1.76u as=0.1496p ps=1.12u w=0.44u l=0.28u
X716 a_5830_28419# a_5799_27913# VDD VDD pfet_03v3 ad=0.1936p pd=1.76u as=0.1496p ps=1.12u w=0.44u l=0.28u
X717 RBL[148] a_4555_20241# VSS VSS nfet_03v3 ad=0.1516p pd=1.64u as=0.1516p ps=1.64u w=0.22u l=0.28u
X718 a_4586_8691# WL[7] WBL[4] VSS nfet_03v3 ad=0.1397p pd=1.22u as=0.1706p ps=1.7u w=0.32u l=0.28u
X719 a_4586_9787# WL[8] WBL[4] VSS nfet_03v3 ad=0.1397p pd=1.22u as=0.1706p ps=1.7u w=0.32u l=0.28u
X720 VDD a_5208_5403# a_5177_4897# VDD pfet_03v3 ad=0.1496p pd=1.12u as=0.1936p ps=1.76u w=0.44u l=0.28u
X721 a_3933_19145# WL[17] WBLB[3] VSS nfet_03v3 ad=0.139p pd=1.215u as=0.2362p ps=2.03u w=0.32u l=0.28u
X722 a_2098_21843# WL[19] WBL[0] VSS nfet_03v3 ad=0.1397p pd=1.22u as=0.1706p ps=1.7u w=0.32u l=0.28u
X723 VSS a_3342_16363# a_3311_15857# VSS nfet_03v3 ad=0.1108p pd=1.1u as=0.139p ps=1.215u w=0.22u l=0.28u
X724 VSS a_3342_17459# a_3311_16953# VSS nfet_03v3 ad=0.1108p pd=1.1u as=0.139p ps=1.215u w=0.22u l=0.28u
X725 VDD a_3342_26227# a_3311_25721# VDD pfet_03v3 ad=0.1496p pd=1.12u as=0.1936p ps=1.76u w=0.44u l=0.28u
X726 RBL[226] a_3342_31707# A[28] VSS nfet_03v3 ad=0.1516p pd=1.64u as=0.1516p ps=1.64u w=0.22u l=0.28u
X727 RBL[203] a_3964_28419# A[25] VSS nfet_03v3 ad=0.1516p pd=1.64u as=0.1516p ps=1.64u w=0.22u l=0.28u
X728 RBL[195] a_3964_27323# A[24] VSS nfet_03v3 ad=0.1516p pd=1.64u as=0.1516p ps=1.64u w=0.22u l=0.28u
X729 RBL[69] a_5177_9281# VSS VSS nfet_03v3 ad=0.1516p pd=1.64u as=0.1516p ps=1.64u w=0.22u l=0.28u
X730 VSS a_2098_29515# a_2067_29009# VSS nfet_03v3 ad=0.1108p pd=1.1u as=0.139p ps=1.215u w=0.22u l=0.28u
X731 RBL[61] a_5177_8185# VSS VSS nfet_03v3 ad=0.1516p pd=1.64u as=0.1516p ps=1.64u w=0.22u l=0.28u
X732 VSS a_5830_16363# a_5799_15857# VSS nfet_03v3 ad=0.1108p pd=1.1u as=0.139p ps=1.215u w=0.22u l=0.28u
X733 VSS a_5830_17459# a_5799_16953# VSS nfet_03v3 ad=0.1108p pd=1.1u as=0.139p ps=1.215u w=0.22u l=0.28u
X734 VDD a_5830_26227# a_5799_25721# VDD pfet_03v3 ad=0.1496p pd=1.12u as=0.1936p ps=1.76u w=0.44u l=0.28u
X735 VSS a_6452_14171# a_6421_13665# VSS nfet_03v3 ad=0.1108p pd=1.1u as=0.139p ps=1.215u w=0.22u l=0.28u
X736 VSS a_6452_13075# a_6421_12569# VSS nfet_03v3 ad=0.1108p pd=1.1u as=0.139p ps=1.215u w=0.22u l=0.28u
X737 a_2689_8185# WL[7] WBLB[1] VSS nfet_03v3 ad=0.139p pd=1.215u as=0.2362p ps=2.03u w=0.32u l=0.28u
X738 a_2689_9281# WL[8] WBLB[1] VSS nfet_03v3 ad=0.139p pd=1.215u as=0.2362p ps=2.03u w=0.32u l=0.28u
X739 RBL[84] a_4555_11473# A[10] VDD pfet_03v3 ad=0.2082p pd=1.84u as=0.2024p ps=1.8u w=0.44u l=0.28u
X740 RBL[121] a_2720_17459# A[15] VSS nfet_03v3 ad=0.1516p pd=1.64u as=0.1516p ps=1.64u w=0.22u l=0.28u
X741 a_3342_10883# WL[9] WBL[2] VSS nfet_03v3 ad=0.1397p pd=1.22u as=0.1706p ps=1.7u w=0.32u l=0.28u
X742 a_3342_11979# WL[10] WBL[2] VSS nfet_03v3 ad=0.1397p pd=1.22u as=0.1706p ps=1.7u w=0.32u l=0.28u
X743 RBL[113] a_2720_16363# A[14] VSS nfet_03v3 ad=0.1516p pd=1.64u as=0.1516p ps=1.64u w=0.22u l=0.28u
X744 RBL[163] a_3933_22433# A[20] VDD pfet_03v3 ad=0.2082p pd=1.84u as=0.2024p ps=1.8u w=0.44u l=0.28u
X745 a_3342_3211# a_3311_2705# VSS VSS nfet_03v3 ad=0.1397p pd=1.22u as=0.1108p ps=1.1u w=0.22u l=0.28u
X746 a_3342_2115# a_3311_1609# VSS VSS nfet_03v3 ad=0.1397p pd=1.22u as=0.1108p ps=1.1u w=0.22u l=0.28u
X747 RBL[68] a_4555_9281# A[8] VDD pfet_03v3 ad=0.2082p pd=1.84u as=0.2024p ps=1.8u w=0.44u l=0.28u
X748 a_3964_9787# a_3933_9281# VSS VSS nfet_03v3 ad=0.1397p pd=1.22u as=0.1108p ps=1.1u w=0.22u l=0.28u
X749 RBL[246] a_5799_33393# A[30] VDD pfet_03v3 ad=0.2082p pd=1.84u as=0.2024p ps=1.8u w=0.44u l=0.28u
X750 a_2720_7595# WL[6] WBL[1] VSS nfet_03v3 ad=0.1397p pd=1.22u as=0.1706p ps=1.7u w=0.32u l=0.28u
X751 RBL[94] a_5830_13075# A[11] VSS nfet_03v3 ad=0.1516p pd=1.64u as=0.1516p ps=1.64u w=0.22u l=0.28u
X752 RBL[85] a_5177_11473# A[10] VDD pfet_03v3 ad=0.2082p pd=1.84u as=0.2024p ps=1.8u w=0.44u l=0.28u
X753 a_2720_34995# a_2689_34489# VSS VSS nfet_03v3 ad=0.1397p pd=1.22u as=0.1108p ps=1.1u w=0.22u l=0.28u
X754 RBL[14] a_5830_2115# A[1] VSS nfet_03v3 ad=0.1516p pd=1.64u as=0.1516p ps=1.64u w=0.22u l=0.28u
X755 a_6421_20241# WL[18] WBLB[7] VSS nfet_03v3 ad=0.139p pd=1.215u as=0.2362p ps=2.03u w=0.32u l=0.28u
X756 RBL[255] a_6421_34489# A[31] VDD pfet_03v3 ad=0.2082p pd=1.84u as=0.2024p ps=1.8u w=0.44u l=0.28u
X757 a_4555_12569# WL[11] WBLB[4] VSS nfet_03v3 ad=0.139p pd=1.215u as=0.2362p ps=2.03u w=0.32u l=0.28u
X758 RBL[251] a_3964_34995# A[31] VSS nfet_03v3 ad=0.1516p pd=1.64u as=0.1516p ps=1.64u w=0.22u l=0.28u
X759 VDD a_4586_14171# a_4555_13665# VDD pfet_03v3 ad=0.1496p pd=1.12u as=0.1936p ps=1.76u w=0.44u l=0.28u
X760 VDD a_3964_25131# a_3933_24625# VDD pfet_03v3 ad=0.1496p pd=1.12u as=0.1936p ps=1.76u w=0.44u l=0.28u
X761 RBL[148] a_4586_20747# A[18] VSS nfet_03v3 ad=0.1516p pd=1.64u as=0.1516p ps=1.64u w=0.22u l=0.28u
X762 RBL[196] a_4555_26817# A[24] VDD pfet_03v3 ad=0.2082p pd=1.84u as=0.2024p ps=1.8u w=0.44u l=0.28u
X763 RBL[134] a_5799_18049# VSS VSS nfet_03v3 ad=0.1516p pd=1.64u as=0.1516p ps=1.64u w=0.22u l=0.28u
X764 RBL[188] a_4555_25721# A[23] VDD pfet_03v3 ad=0.2082p pd=1.84u as=0.2024p ps=1.8u w=0.44u l=0.28u
X765 RBL[58] a_3311_8185# VSS VSS nfet_03v3 ad=0.1516p pd=1.64u as=0.1516p ps=1.64u w=0.22u l=0.28u
X766 RBL[66] a_3311_9281# VSS VSS nfet_03v3 ad=0.1516p pd=1.64u as=0.1516p ps=1.64u w=0.22u l=0.28u
X767 VSS a_5208_5403# a_5177_4897# VSS nfet_03v3 ad=0.1108p pd=1.1u as=0.139p ps=1.215u w=0.22u l=0.28u
X768 RBL[129] a_2689_18049# A[16] VDD pfet_03v3 ad=0.2082p pd=1.84u as=0.2024p ps=1.8u w=0.44u l=0.28u
X769 RBL[137] a_2689_19145# A[17] VDD pfet_03v3 ad=0.2082p pd=1.84u as=0.2024p ps=1.8u w=0.44u l=0.28u
X770 RBL[208] a_2067_29009# A[26] VDD pfet_03v3 ad=0.2082p pd=1.84u as=0.2024p ps=1.8u w=0.44u l=0.28u
X771 VDD a_2098_16363# a_2067_15857# VDD pfet_03v3 ad=0.1496p pd=1.12u as=0.1936p ps=1.76u w=0.44u l=0.28u
X772 RBL[5] a_5208_1019# A[0] VSS nfet_03v3 ad=0.1516p pd=1.64u as=0.1516p ps=1.64u w=0.22u l=0.28u
X773 a_5830_19651# WL[17] WBL[6] VSS nfet_03v3 ad=0.1397p pd=1.22u as=0.1706p ps=1.7u w=0.32u l=0.28u
X774 RBL[152] a_2098_21843# A[19] VSS nfet_03v3 ad=0.1516p pd=1.64u as=0.1516p ps=1.64u w=0.22u l=0.28u
X775 RBL[160] a_2098_22939# A[20] VSS nfet_03v3 ad=0.1516p pd=1.64u as=0.1516p ps=1.64u w=0.22u l=0.28u
X776 a_2689_34489# WL[31] WBLB[1] VSS nfet_03v3 ad=0.139p pd=1.215u as=0.2362p ps=2.03u w=0.32u l=0.28u
X777 a_3311_31201# WL[28] WBLB[2] VSS nfet_03v3 ad=0.139p pd=1.215u as=0.2362p ps=2.03u w=0.32u l=0.28u
X778 RBL[197] a_5177_26817# A[24] VDD pfet_03v3 ad=0.2082p pd=1.84u as=0.2024p ps=1.8u w=0.44u l=0.28u
X779 RBL[189] a_5177_25721# A[23] VDD pfet_03v3 ad=0.2082p pd=1.84u as=0.2024p ps=1.8u w=0.44u l=0.28u
X780 VDD a_3342_5403# a_3311_4897# VDD pfet_03v3 ad=0.1496p pd=1.12u as=0.1936p ps=1.76u w=0.44u l=0.28u
X781 a_2098_3211# a_2067_2705# VDD VDD pfet_03v3 ad=0.1936p pd=1.76u as=0.1496p ps=1.12u w=0.44u l=0.28u
X782 a_5208_29515# WL[26] WBL[5] VSS nfet_03v3 ad=0.1397p pd=1.22u as=0.1706p ps=1.7u w=0.32u l=0.28u
X783 RBL[58] a_3342_8691# A[7] VSS nfet_03v3 ad=0.1516p pd=1.64u as=0.1516p ps=1.64u w=0.22u l=0.28u
X784 RBL[66] a_3342_9787# A[8] VSS nfet_03v3 ad=0.1516p pd=1.64u as=0.1516p ps=1.64u w=0.22u l=0.28u
X785 VSS a_5208_34995# a_5177_34489# VSS nfet_03v3 ad=0.1108p pd=1.1u as=0.139p ps=1.215u w=0.22u l=0.28u
X786 RBL[11] a_3964_2115# A[1] VSS nfet_03v3 ad=0.1516p pd=1.64u as=0.1516p ps=1.64u w=0.22u l=0.28u
X787 VSS a_4586_13075# a_4555_12569# VSS nfet_03v3 ad=0.1108p pd=1.1u as=0.139p ps=1.215u w=0.22u l=0.28u
X788 VSS a_4586_14171# a_4555_13665# VSS nfet_03v3 ad=0.1108p pd=1.1u as=0.139p ps=1.215u w=0.22u l=0.28u
X789 a_2720_21843# a_2689_21337# VDD VDD pfet_03v3 ad=0.1936p pd=1.76u as=0.1496p ps=1.12u w=0.44u l=0.28u
X790 VDD a_3964_32803# a_3933_32297# VDD pfet_03v3 ad=0.1496p pd=1.12u as=0.1936p ps=1.76u w=0.44u l=0.28u
X791 VSS a_3964_25131# a_3933_24625# VSS nfet_03v3 ad=0.1108p pd=1.1u as=0.139p ps=1.215u w=0.22u l=0.28u
X792 VSS a_3964_24035# a_3933_23529# VSS nfet_03v3 ad=0.1108p pd=1.1u as=0.139p ps=1.215u w=0.22u l=0.28u
X793 a_5830_4307# a_5799_3801# VDD VDD pfet_03v3 ad=0.1936p pd=1.76u as=0.1496p ps=1.12u w=0.44u l=0.28u
X794 RBL[69] a_5177_9281# A[8] VDD pfet_03v3 ad=0.2082p pd=1.84u as=0.2024p ps=1.8u w=0.44u l=0.28u
X795 VDD a_3342_17459# a_3311_16953# VDD pfet_03v3 ad=0.1496p pd=1.12u as=0.1936p ps=1.76u w=0.44u l=0.28u
X796 VDD a_3342_18555# a_3311_18049# VDD pfet_03v3 ad=0.1496p pd=1.12u as=0.1936p ps=1.76u w=0.44u l=0.28u
X797 RBL[91] a_3964_13075# A[11] VSS nfet_03v3 ad=0.1516p pd=1.64u as=0.1516p ps=1.64u w=0.22u l=0.28u
X798 RBL[170] a_3342_24035# A[21] VSS nfet_03v3 ad=0.1516p pd=1.64u as=0.1516p ps=1.64u w=0.22u l=0.28u
X799 VDD a_5830_17459# a_5799_16953# VDD pfet_03v3 ad=0.1496p pd=1.12u as=0.1936p ps=1.76u w=0.44u l=0.28u
X800 VDD a_5830_18555# a_5799_18049# VDD pfet_03v3 ad=0.1496p pd=1.12u as=0.1936p ps=1.76u w=0.44u l=0.28u
X801 RBL[82] a_3311_11473# A[10] VDD pfet_03v3 ad=0.2082p pd=1.84u as=0.2024p ps=1.8u w=0.44u l=0.28u
X802 VDD a_6452_15267# a_6421_14761# VDD pfet_03v3 ad=0.1496p pd=1.12u as=0.1936p ps=1.76u w=0.44u l=0.28u
X803 a_6421_30105# WL[27] WBLB[7] VSS nfet_03v3 ad=0.139p pd=1.215u as=0.2362p ps=2.03u w=0.32u l=0.28u
X804 RBL[252] a_4555_34489# A[31] VDD pfet_03v3 ad=0.2082p pd=1.84u as=0.2024p ps=1.8u w=0.44u l=0.28u
X805 RBL[233] a_2720_32803# A[29] VSS nfet_03v3 ad=0.1516p pd=1.64u as=0.1516p ps=1.64u w=0.22u l=0.28u
X806 a_4555_3801# WL[3] WBLB[4] VSS nfet_03v3 ad=0.139p pd=1.215u as=0.2362p ps=2.03u w=0.32u l=0.28u
X807 a_4586_20747# WL[18] WBL[4] VSS nfet_03v3 ad=0.1397p pd=1.22u as=0.1706p ps=1.7u w=0.32u l=0.28u
X808 a_4555_2705# WL[2] WBLB[4] VSS nfet_03v3 ad=0.139p pd=1.215u as=0.2362p ps=2.03u w=0.32u l=0.28u
X809 a_2689_12569# WL[11] WBLB[1] VSS nfet_03v3 ad=0.139p pd=1.215u as=0.2362p ps=2.03u w=0.32u l=0.28u
X810 VDD a_2098_25131# a_2067_24625# VDD pfet_03v3 ad=0.1496p pd=1.12u as=0.1936p ps=1.76u w=0.44u l=0.28u
X811 VDD a_5830_2115# a_5799_1609# VDD pfet_03v3 ad=0.1496p pd=1.12u as=0.1936p ps=1.76u w=0.44u l=0.28u
X812 RBL[6] a_5799_513# VSS VSS nfet_03v3 ad=0.1516p pd=1.64u as=0.1516p ps=1.64u w=0.22u l=0.28u
X813 a_2720_20747# a_2689_20241# VSS VSS nfet_03v3 ad=0.1397p pd=1.22u as=0.1108p ps=1.1u w=0.22u l=0.28u
X814 a_2098_31707# a_2067_31201# VSS VSS nfet_03v3 ad=0.1397p pd=1.22u as=0.1108p ps=1.1u w=0.22u l=0.28u
X815 RBL[216] a_2098_30611# A[27] VSS nfet_03v3 ad=0.1516p pd=1.64u as=0.1516p ps=1.64u w=0.22u l=0.28u
X816 a_3342_8691# WL[7] WBL[2] VSS nfet_03v3 ad=0.1397p pd=1.22u as=0.1706p ps=1.7u w=0.32u l=0.28u
X817 a_3342_9787# WL[8] WBL[2] VSS nfet_03v3 ad=0.1397p pd=1.22u as=0.1706p ps=1.7u w=0.32u l=0.28u
X818 RBL[131] a_3933_18049# VSS VSS nfet_03v3 ad=0.1516p pd=1.64u as=0.1516p ps=1.64u w=0.22u l=0.28u
X819 VSS a_3342_5403# a_3311_4897# VSS nfet_03v3 ad=0.1108p pd=1.1u as=0.139p ps=1.215u w=0.22u l=0.28u
X820 a_5177_20241# WL[18] WBLB[5] VSS nfet_03v3 ad=0.139p pd=1.215u as=0.2362p ps=2.03u w=0.32u l=0.28u
X821 RBL[253] a_5177_34489# A[31] VDD pfet_03v3 ad=0.2082p pd=1.84u as=0.2024p ps=1.8u w=0.44u l=0.28u
X822 RBL[151] a_6421_20241# A[18] VDD pfet_03v3 ad=0.2082p pd=1.84u as=0.2024p ps=1.8u w=0.44u l=0.28u
X823 VDD a_5208_21843# a_5177_21337# VDD pfet_03v3 ad=0.1496p pd=1.12u as=0.1936p ps=1.76u w=0.44u l=0.28u
X824 RBL[159] a_6421_21337# A[19] VDD pfet_03v3 ad=0.2082p pd=1.84u as=0.2024p ps=1.8u w=0.44u l=0.28u
X825 VDD a_2720_29515# a_2689_29009# VDD pfet_03v3 ad=0.1496p pd=1.12u as=0.1936p ps=1.76u w=0.44u l=0.28u
X826 VDD a_2720_28419# a_2689_27913# VDD pfet_03v3 ad=0.1496p pd=1.12u as=0.1936p ps=1.76u w=0.44u l=0.28u
X827 VDD a_3964_10883# a_3933_10377# VDD pfet_03v3 ad=0.1496p pd=1.12u as=0.1936p ps=1.76u w=0.44u l=0.28u
X828 RBL[12] a_4555_1609# VSS VSS nfet_03v3 ad=0.1516p pd=1.64u as=0.1516p ps=1.64u w=0.22u l=0.28u
X829 a_3964_19651# a_3933_19145# VDD VDD pfet_03v3 ad=0.1936p pd=1.76u as=0.1496p ps=1.12u w=0.44u l=0.28u
X830 RBL[66] a_3311_9281# A[8] VDD pfet_03v3 ad=0.2082p pd=1.84u as=0.2024p ps=1.8u w=0.44u l=0.28u
X831 RBL[194] a_3311_26817# A[24] VDD pfet_03v3 ad=0.2082p pd=1.84u as=0.2024p ps=1.8u w=0.44u l=0.28u
X832 RBL[186] a_3311_25721# A[23] VDD pfet_03v3 ad=0.2082p pd=1.84u as=0.2024p ps=1.8u w=0.44u l=0.28u
X833 a_5799_21337# WL[19] WBLB[6] VSS nfet_03v3 ad=0.139p pd=1.215u as=0.2362p ps=2.03u w=0.32u l=0.28u
X834 a_5830_15267# a_5799_14761# VSS VSS nfet_03v3 ad=0.1397p pd=1.22u as=0.1108p ps=1.1u w=0.22u l=0.28u
X835 a_5830_4307# a_5799_3801# VSS VSS nfet_03v3 ad=0.1397p pd=1.22u as=0.1108p ps=1.1u w=0.22u l=0.28u
X836 a_4586_4307# WL[3] WBL[4] VSS nfet_03v3 ad=0.1397p pd=1.22u as=0.1706p ps=1.7u w=0.32u l=0.28u
X837 a_4586_3211# WL[2] WBL[4] VSS nfet_03v3 ad=0.1397p pd=1.22u as=0.1706p ps=1.7u w=0.32u l=0.28u
X838 a_3933_13665# WL[12] WBLB[3] VSS nfet_03v3 ad=0.139p pd=1.215u as=0.2362p ps=2.03u w=0.32u l=0.28u
X839 a_3933_14761# WL[13] WBLB[3] VSS nfet_03v3 ad=0.139p pd=1.215u as=0.2362p ps=2.03u w=0.32u l=0.28u
X840 RBL[112] a_2067_15857# A[14] VDD pfet_03v3 ad=0.2082p pd=1.84u as=0.2024p ps=1.8u w=0.44u l=0.28u
X841 RBL[104] a_2067_14761# A[13] VDD pfet_03v3 ad=0.2082p pd=1.84u as=0.2024p ps=1.8u w=0.44u l=0.28u
X842 a_2067_31201# WL[28] WBLB[0] VSS nfet_03v3 ad=0.139p pd=1.215u as=0.2362p ps=2.03u w=0.32u l=0.28u
X843 VSS a_2098_25131# a_2067_24625# VSS nfet_03v3 ad=0.1108p pd=1.1u as=0.139p ps=1.215u w=0.22u l=0.28u
X844 VSS a_2098_24035# a_2067_23529# VSS nfet_03v3 ad=0.1108p pd=1.1u as=0.139p ps=1.215u w=0.22u l=0.28u
X845 RBL[141] a_5177_19145# VSS VSS nfet_03v3 ad=0.1516p pd=1.64u as=0.1516p ps=1.64u w=0.22u l=0.28u
X846 VDD a_2098_32803# a_2067_32297# VDD pfet_03v3 ad=0.1496p pd=1.12u as=0.1936p ps=1.76u w=0.44u l=0.28u
X847 VSS a_5830_7595# a_5799_7089# VSS nfet_03v3 ad=0.1108p pd=1.1u as=0.139p ps=1.215u w=0.22u l=0.28u
X848 VDD a_6452_24035# a_6421_23529# VDD pfet_03v3 ad=0.1496p pd=1.12u as=0.1936p ps=1.76u w=0.44u l=0.28u
X849 a_2689_3801# WL[3] WBLB[1] VSS nfet_03v3 ad=0.139p pd=1.215u as=0.2362p ps=2.03u w=0.32u l=0.28u
X850 a_2689_2705# WL[2] WBLB[1] VSS nfet_03v3 ad=0.139p pd=1.215u as=0.2362p ps=2.03u w=0.32u l=0.28u
X851 a_6452_16363# a_6421_15857# VSS VSS nfet_03v3 ad=0.1397p pd=1.22u as=0.1108p ps=1.1u w=0.22u l=0.28u
X852 a_6452_17459# a_6421_16953# VSS VSS nfet_03v3 ad=0.1397p pd=1.22u as=0.1108p ps=1.1u w=0.22u l=0.28u
X853 VDD a_6452_22939# a_6421_22433# VDD pfet_03v3 ad=0.1496p pd=1.12u as=0.1936p ps=1.76u w=0.44u l=0.28u
X854 a_6452_26227# a_6421_25721# VDD VDD pfet_03v3 ad=0.1936p pd=1.76u as=0.1496p ps=1.12u w=0.44u l=0.28u
X855 a_3964_29515# WL[26] WBL[3] VSS nfet_03v3 ad=0.1397p pd=1.22u as=0.1706p ps=1.7u w=0.32u l=0.28u
X856 RBL[3] a_3933_513# VSS VSS nfet_03v3 ad=0.1516p pd=1.64u as=0.1516p ps=1.64u w=0.22u l=0.28u
X857 VSS a_5208_20747# a_5177_20241# VSS nfet_03v3 ad=0.1108p pd=1.1u as=0.139p ps=1.215u w=0.22u l=0.28u
X858 a_6421_5993# WL[5] WBLB[7] VSS nfet_03v3 ad=0.139p pd=1.215u as=0.2362p ps=2.03u w=0.32u l=0.28u
X859 a_6421_4897# WL[4] WBLB[7] VSS nfet_03v3 ad=0.139p pd=1.215u as=0.2362p ps=2.03u w=0.32u l=0.28u
X860 VDD a_4586_15267# a_4555_14761# VDD pfet_03v3 ad=0.1496p pd=1.12u as=0.1936p ps=1.76u w=0.44u l=0.28u
X861 a_3964_18555# a_3933_18049# VSS VSS nfet_03v3 ad=0.1397p pd=1.22u as=0.1108p ps=1.1u w=0.22u l=0.28u
X862 a_3964_19651# a_3933_19145# VSS VSS nfet_03v3 ad=0.1397p pd=1.22u as=0.1108p ps=1.1u w=0.22u l=0.28u
X863 a_3964_27323# a_3933_26817# VDD VDD pfet_03v3 ad=0.1936p pd=1.76u as=0.1496p ps=1.12u w=0.44u l=0.28u
X864 a_4586_30611# WL[27] WBL[4] VSS nfet_03v3 ad=0.1397p pd=1.22u as=0.1706p ps=1.7u w=0.32u l=0.28u
X865 a_5830_29515# a_5799_29009# VSS VSS nfet_03v3 ad=0.1397p pd=1.22u as=0.1108p ps=1.1u w=0.22u l=0.28u
X866 a_3933_22433# WL[20] WBLB[3] VSS nfet_03v3 ad=0.139p pd=1.215u as=0.2362p ps=2.03u w=0.32u l=0.28u
X867 VSS a_5208_6499# a_5177_5993# VSS nfet_03v3 ad=0.1108p pd=1.1u as=0.139p ps=1.215u w=0.22u l=0.28u
X868 RBL[23] a_6421_2705# VSS VSS nfet_03v3 ad=0.1516p pd=1.64u as=0.1516p ps=1.64u w=0.22u l=0.28u
X869 VSS a_3342_26227# a_3311_25721# VSS nfet_03v3 ad=0.1108p pd=1.1u as=0.139p ps=1.215u w=0.22u l=0.28u
X870 VDD a_3342_34995# a_3311_34489# VDD pfet_03v3 ad=0.1496p pd=1.12u as=0.1936p ps=1.76u w=0.44u l=0.28u
X871 VDD a_3342_33899# a_3311_33393# VDD pfet_03v3 ad=0.1496p pd=1.12u as=0.1936p ps=1.76u w=0.44u l=0.28u
X872 a_5177_30105# WL[27] WBLB[5] VSS nfet_03v3 ad=0.139p pd=1.215u as=0.2362p ps=2.03u w=0.32u l=0.28u
X873 VDD a_5830_34995# a_5799_34489# VDD pfet_03v3 ad=0.1496p pd=1.12u as=0.1936p ps=1.76u w=0.44u l=0.28u
X874 VDD a_5830_33899# a_5799_33393# VDD pfet_03v3 ad=0.1496p pd=1.12u as=0.1936p ps=1.76u w=0.44u l=0.28u
X875 VSS a_5830_26227# a_5799_25721# VSS nfet_03v3 ad=0.1108p pd=1.1u as=0.139p ps=1.215u w=0.22u l=0.28u
X876 VSS a_6452_21843# a_6421_21337# VSS nfet_03v3 ad=0.1108p pd=1.1u as=0.139p ps=1.215u w=0.22u l=0.28u
X877 VSS a_6452_22939# a_6421_22433# VSS nfet_03v3 ad=0.1108p pd=1.1u as=0.139p ps=1.215u w=0.22u l=0.28u
X878 RBL[250] a_3311_34489# A[31] VDD pfet_03v3 ad=0.2082p pd=1.84u as=0.2024p ps=1.8u w=0.44u l=0.28u
X879 VDD a_6452_31707# a_6421_31201# VDD pfet_03v3 ad=0.1496p pd=1.12u as=0.1936p ps=1.76u w=0.44u l=0.28u
X880 VDD a_6452_30611# a_6421_30105# VDD pfet_03v3 ad=0.1496p pd=1.12u as=0.1936p ps=1.76u w=0.44u l=0.28u
X881 a_2720_18555# WL[16] WBL[1] VSS nfet_03v3 ad=0.1397p pd=1.22u as=0.1706p ps=1.7u w=0.32u l=0.28u
X882 RBL[148] a_4555_20241# A[18] VDD pfet_03v3 ad=0.2082p pd=1.84u as=0.2024p ps=1.8u w=0.44u l=0.28u
X883 RBL[156] a_4555_21337# A[19] VDD pfet_03v3 ad=0.2082p pd=1.84u as=0.2024p ps=1.8u w=0.44u l=0.28u
X884 RBL[235] a_3933_32297# A[29] VDD pfet_03v3 ad=0.2082p pd=1.84u as=0.2024p ps=1.8u w=0.44u l=0.28u
X885 RBL[227] a_3933_31201# A[28] VDD pfet_03v3 ad=0.2082p pd=1.84u as=0.2024p ps=1.8u w=0.44u l=0.28u
X886 RBL[185] a_2720_26227# A[23] VSS nfet_03v3 ad=0.1516p pd=1.64u as=0.1516p ps=1.64u w=0.22u l=0.28u
X887 RBL[177] a_2720_25131# A[22] VSS nfet_03v3 ad=0.1516p pd=1.64u as=0.1516p ps=1.64u w=0.22u l=0.28u
X888 a_2098_4307# a_2067_3801# VDD VDD pfet_03v3 ad=0.1936p pd=1.76u as=0.1496p ps=1.12u w=0.44u l=0.28u
X889 a_3342_20747# WL[18] WBL[2] VSS nfet_03v3 ad=0.1397p pd=1.22u as=0.1706p ps=1.7u w=0.32u l=0.28u
X890 RBL[89] a_2689_12569# A[11] VDD pfet_03v3 ad=0.2082p pd=1.84u as=0.2024p ps=1.8u w=0.44u l=0.28u
X891 RBL[168] a_2067_23529# A[21] VDD pfet_03v3 ad=0.2082p pd=1.84u as=0.2024p ps=1.8u w=0.44u l=0.28u
X892 VDD a_2098_10883# a_2067_10377# VDD pfet_03v3 ad=0.1496p pd=1.12u as=0.1936p ps=1.76u w=0.44u l=0.28u
X893 a_5830_15267# WL[13] WBL[6] VSS nfet_03v3 ad=0.1397p pd=1.22u as=0.1706p ps=1.7u w=0.32u l=0.28u
X894 RBL[141] a_5208_19651# A[17] VSS nfet_03v3 ad=0.1516p pd=1.64u as=0.1516p ps=1.64u w=0.22u l=0.28u
X895 RBL[23] a_6452_3211# A[2] VSS nfet_03v3 ad=0.1516p pd=1.64u as=0.1516p ps=1.64u w=0.22u l=0.28u
X896 a_5830_14171# WL[12] WBL[6] VSS nfet_03v3 ad=0.1397p pd=1.22u as=0.1706p ps=1.7u w=0.32u l=0.28u
X897 RBL[158] a_5830_21843# A[19] VSS nfet_03v3 ad=0.1516p pd=1.64u as=0.1516p ps=1.64u w=0.22u l=0.28u
X898 RBL[166] a_5830_22939# A[20] VSS nfet_03v3 ad=0.1516p pd=1.64u as=0.1516p ps=1.64u w=0.22u l=0.28u
X899 a_4555_513# WL[0] WBLB[4] VSS nfet_03v3 ad=0.139p pd=1.215u as=0.2362p ps=2.03u w=0.32u l=0.28u
X900 RBL[149] a_5177_20241# A[18] VDD pfet_03v3 ad=0.2082p pd=1.84u as=0.2024p ps=1.8u w=0.44u l=0.28u
X901 RBL[157] a_5177_21337# A[19] VDD pfet_03v3 ad=0.2082p pd=1.84u as=0.2024p ps=1.8u w=0.44u l=0.28u
X902 RBL[138] a_3311_19145# VSS VSS nfet_03v3 ad=0.1516p pd=1.64u as=0.1516p ps=1.64u w=0.22u l=0.28u
X903 a_4555_21337# WL[19] WBLB[4] VSS nfet_03v3 ad=0.139p pd=1.215u as=0.2362p ps=2.03u w=0.32u l=0.28u
X904 VDD a_4586_24035# a_4555_23529# VDD pfet_03v3 ad=0.1496p pd=1.12u as=0.1936p ps=1.76u w=0.44u l=0.28u
X905 RBL[0] a_2067_513# VSS VSS nfet_03v3 ad=0.1516p pd=1.64u as=0.1516p ps=1.64u w=0.22u l=0.28u
X906 RBL[0] a_2098_1019# A[0] VSS nfet_03v3 ad=0.1516p pd=1.64u as=0.1516p ps=1.64u w=0.22u l=0.28u
X907 a_3964_28419# a_3933_27913# VSS VSS nfet_03v3 ad=0.1397p pd=1.22u as=0.1108p ps=1.1u w=0.22u l=0.28u
X908 a_4586_26227# a_4555_25721# VDD VDD pfet_03v3 ad=0.1936p pd=1.76u as=0.1496p ps=1.12u w=0.44u l=0.28u
X909 a_4586_16363# a_4555_15857# VSS VSS nfet_03v3 ad=0.1397p pd=1.22u as=0.1108p ps=1.1u w=0.22u l=0.28u
X910 a_4586_17459# a_4555_16953# VSS VSS nfet_03v3 ad=0.1397p pd=1.22u as=0.1108p ps=1.1u w=0.22u l=0.28u
X911 VDD a_4586_22939# a_4555_22433# VDD pfet_03v3 ad=0.1496p pd=1.12u as=0.1936p ps=1.76u w=0.44u l=0.28u
X912 a_3964_27323# a_3933_26817# VSS VSS nfet_03v3 ad=0.1397p pd=1.22u as=0.1108p ps=1.1u w=0.22u l=0.28u
X913 a_5830_16363# a_5799_15857# VDD VDD pfet_03v3 ad=0.1936p pd=1.76u as=0.1496p ps=1.12u w=0.44u l=0.28u
X914 RBL[206] a_5799_27913# VSS VSS nfet_03v3 ad=0.1516p pd=1.64u as=0.1516p ps=1.64u w=0.22u l=0.28u
X915 RBL[198] a_5799_26817# VSS VSS nfet_03v3 ad=0.1516p pd=1.64u as=0.1516p ps=1.64u w=0.22u l=0.28u
X916 a_2720_26227# WL[23] WBL[1] VSS nfet_03v3 ad=0.1397p pd=1.22u as=0.1706p ps=1.7u w=0.32u l=0.28u
X917 a_2720_25131# WL[22] WBL[1] VSS nfet_03v3 ad=0.1397p pd=1.22u as=0.1706p ps=1.7u w=0.32u l=0.28u
X918 RBL[17] a_2689_2705# A[2] VDD pfet_03v3 ad=0.2082p pd=1.84u as=0.2024p ps=1.8u w=0.44u l=0.28u
X919 RBL[9] a_2689_1609# A[1] VDD pfet_03v3 ad=0.2082p pd=1.84u as=0.2024p ps=1.8u w=0.44u l=0.28u
X920 RBL[119] a_6421_15857# VSS VSS nfet_03v3 ad=0.1516p pd=1.64u as=0.1516p ps=1.64u w=0.22u l=0.28u
X921 RBL[127] a_6421_16953# VSS VSS nfet_03v3 ad=0.1516p pd=1.64u as=0.1516p ps=1.64u w=0.22u l=0.28u
X922 RBL[241] a_2720_33899# A[30] VSS nfet_03v3 ad=0.1516p pd=1.64u as=0.1516p ps=1.64u w=0.22u l=0.28u
X923 VDD a_3342_13075# a_3311_12569# VDD pfet_03v3 ad=0.1496p pd=1.12u as=0.1936p ps=1.76u w=0.44u l=0.28u
X924 VDD a_3342_11979# a_3311_11473# VDD pfet_03v3 ad=0.1496p pd=1.12u as=0.1936p ps=1.76u w=0.44u l=0.28u
X925 RBL[39] a_6421_4897# A[4] VDD pfet_03v3 ad=0.2082p pd=1.84u as=0.2024p ps=1.8u w=0.44u l=0.28u
X926 RBL[31] a_6421_3801# A[3] VDD pfet_03v3 ad=0.2082p pd=1.84u as=0.2024p ps=1.8u w=0.44u l=0.28u
X927 VDD a_3964_6499# a_3933_5993# VDD pfet_03v3 ad=0.1496p pd=1.12u as=0.1936p ps=1.76u w=0.44u l=0.28u
X928 VDD a_3964_7595# a_3933_7089# VDD pfet_03v3 ad=0.1496p pd=1.12u as=0.1936p ps=1.76u w=0.44u l=0.28u
X929 RBL[201] a_2689_27913# A[25] VDD pfet_03v3 ad=0.2082p pd=1.84u as=0.2024p ps=1.8u w=0.44u l=0.28u
X930 VDD a_5830_11979# a_5799_11473# VDD pfet_03v3 ad=0.1496p pd=1.12u as=0.1936p ps=1.76u w=0.44u l=0.28u
X931 VDD a_5830_13075# a_5799_12569# VDD pfet_03v3 ad=0.1496p pd=1.12u as=0.1936p ps=1.76u w=0.44u l=0.28u
X932 a_5830_22939# WL[20] WBL[6] VSS nfet_03v3 ad=0.1397p pd=1.22u as=0.1706p ps=1.7u w=0.32u l=0.28u
X933 a_5208_16363# a_5177_15857# VSS VSS nfet_03v3 ad=0.1397p pd=1.22u as=0.1108p ps=1.1u w=0.22u l=0.28u
X934 a_5208_17459# a_5177_16953# VSS VSS nfet_03v3 ad=0.1397p pd=1.22u as=0.1108p ps=1.1u w=0.22u l=0.28u
X935 a_5208_26227# a_5177_25721# VDD VDD pfet_03v3 ad=0.1936p pd=1.76u as=0.1496p ps=1.12u w=0.44u l=0.28u
X936 a_6452_17459# a_6421_16953# VDD VDD pfet_03v3 ad=0.1936p pd=1.76u as=0.1496p ps=1.12u w=0.44u l=0.28u
X937 a_6452_18555# a_6421_18049# VDD VDD pfet_03v3 ad=0.1936p pd=1.76u as=0.1496p ps=1.12u w=0.44u l=0.28u
X938 a_3964_5403# a_3933_4897# VDD VDD pfet_03v3 ad=0.1936p pd=1.76u as=0.1496p ps=1.12u w=0.44u l=0.28u
X939 VSS a_3342_6499# a_3311_5993# VSS nfet_03v3 ad=0.1108p pd=1.1u as=0.139p ps=1.215u w=0.22u l=0.28u
X940 RBL[20] a_4586_3211# A[2] VSS nfet_03v3 ad=0.1516p pd=1.64u as=0.1516p ps=1.64u w=0.22u l=0.28u
X941 a_2098_4307# a_2067_3801# VSS VSS nfet_03v3 ad=0.1397p pd=1.22u as=0.1108p ps=1.1u w=0.22u l=0.28u
X942 VDD a_2720_8691# a_2689_8185# VDD pfet_03v3 ad=0.1496p pd=1.12u as=0.1936p ps=1.76u w=0.44u l=0.28u
X943 VDD a_2720_9787# a_2689_9281# VDD pfet_03v3 ad=0.1496p pd=1.12u as=0.1936p ps=1.76u w=0.44u l=0.28u
X944 RBL[222] a_5830_30611# A[27] VSS nfet_03v3 ad=0.1516p pd=1.64u as=0.1516p ps=1.64u w=0.22u l=0.28u
X945 a_3342_30611# WL[27] WBL[2] VSS nfet_03v3 ad=0.1397p pd=1.22u as=0.1706p ps=1.7u w=0.32u l=0.28u
X946 a_3342_4307# WL[3] WBL[2] VSS nfet_03v3 ad=0.1397p pd=1.22u as=0.1706p ps=1.7u w=0.32u l=0.28u
X947 a_3342_3211# WL[2] WBL[2] VSS nfet_03v3 ad=0.1397p pd=1.22u as=0.1706p ps=1.7u w=0.32u l=0.28u
X948 VSS a_3964_33899# a_3933_33393# VSS nfet_03v3 ad=0.1108p pd=1.1u as=0.139p ps=1.215u w=0.22u l=0.28u
X949 VSS a_3964_32803# a_3933_32297# VSS nfet_03v3 ad=0.1108p pd=1.1u as=0.139p ps=1.215u w=0.22u l=0.28u
X950 VDD a_4586_31707# a_4555_31201# VDD pfet_03v3 ad=0.1496p pd=1.12u as=0.1936p ps=1.76u w=0.44u l=0.28u
X951 VDD a_4586_30611# a_4555_30105# VDD pfet_03v3 ad=0.1496p pd=1.12u as=0.1936p ps=1.76u w=0.44u l=0.28u
X952 VSS a_4586_21843# a_4555_21337# VSS nfet_03v3 ad=0.1108p pd=1.1u as=0.139p ps=1.215u w=0.22u l=0.28u
X953 VSS a_4586_22939# a_4555_22433# VSS nfet_03v3 ad=0.1108p pd=1.1u as=0.139p ps=1.215u w=0.22u l=0.28u
X954 a_2720_6499# a_2689_5993# VDD VDD pfet_03v3 ad=0.1936p pd=1.76u as=0.1496p ps=1.12u w=0.44u l=0.28u
X955 a_2720_7595# a_2689_7089# VDD VDD pfet_03v3 ad=0.1936p pd=1.76u as=0.1496p ps=1.12u w=0.44u l=0.28u
X956 VSS a_2720_15267# a_2689_14761# VSS nfet_03v3 ad=0.1108p pd=1.1u as=0.139p ps=1.215u w=0.22u l=0.28u
X957 RBL[254] a_5799_34489# a_6043_35171# VSS nfet_03v3 ad=0.1516p pd=1.64u as=0.1516p ps=1.64u w=0.22u l=0.28u
X958 a_6452_28419# WL[25] WBL[7] VSS nfet_03v3 ad=0.1397p pd=1.22u as=0.1706p ps=1.7u w=0.32u l=0.28u
X959 a_6452_27323# WL[24] WBL[7] VSS nfet_03v3 ad=0.1397p pd=1.22u as=0.1706p ps=1.7u w=0.32u l=0.28u
X960 a_6452_8691# a_6421_8185# VDD VDD pfet_03v3 ad=0.1936p pd=1.76u as=0.1496p ps=1.12u w=0.44u l=0.28u
X961 a_6452_9787# a_6421_9281# VDD VDD pfet_03v3 ad=0.1936p pd=1.76u as=0.1496p ps=1.12u w=0.44u l=0.28u
X962 VSS a_3342_10883# a_3311_10377# VSS nfet_03v3 ad=0.1108p pd=1.1u as=0.139p ps=1.215u w=0.22u l=0.28u
X963 VSS a_3342_11979# a_3311_11473# VSS nfet_03v3 ad=0.1108p pd=1.1u as=0.139p ps=1.215u w=0.22u l=0.28u
X964 RBL[155] a_3964_21843# A[19] VSS nfet_03v3 ad=0.1516p pd=1.64u as=0.1516p ps=1.64u w=0.22u l=0.28u
X965 RBL[163] a_3964_22939# A[20] VSS nfet_03v3 ad=0.1516p pd=1.64u as=0.1516p ps=1.64u w=0.22u l=0.28u
X966 RBL[29] a_5177_3801# VSS VSS nfet_03v3 ad=0.1516p pd=1.64u as=0.1516p ps=1.64u w=0.22u l=0.28u
X967 VSS a_5830_10883# a_5799_10377# VSS nfet_03v3 ad=0.1108p pd=1.1u as=0.139p ps=1.215u w=0.22u l=0.28u
X968 VSS a_5830_11979# a_5799_11473# VSS nfet_03v3 ad=0.1108p pd=1.1u as=0.139p ps=1.215u w=0.22u l=0.28u
X969 a_3964_14171# a_3933_13665# VDD VDD pfet_03v3 ad=0.1936p pd=1.76u as=0.1496p ps=1.12u w=0.44u l=0.28u
X970 RBL[146] a_3311_20241# A[18] VDD pfet_03v3 ad=0.2082p pd=1.84u as=0.2024p ps=1.8u w=0.44u l=0.28u
X971 RBL[154] a_3311_21337# A[19] VDD pfet_03v3 ad=0.2082p pd=1.84u as=0.2024p ps=1.8u w=0.44u l=0.28u
X972 RBL[73] a_2720_10883# A[9] VSS nfet_03v3 ad=0.1516p pd=1.64u as=0.1516p ps=1.64u w=0.22u l=0.28u
X973 RBL[81] a_2720_11979# A[10] VSS nfet_03v3 ad=0.1516p pd=1.64u as=0.1516p ps=1.64u w=0.22u l=0.28u
X974 a_5177_5993# WL[5] WBLB[5] VSS nfet_03v3 ad=0.139p pd=1.215u as=0.2362p ps=2.03u w=0.32u l=0.28u
X975 RBL[36] a_4555_4897# A[4] VDD pfet_03v3 ad=0.2082p pd=1.84u as=0.2024p ps=1.8u w=0.44u l=0.28u
X976 a_5177_4897# WL[4] WBLB[5] VSS nfet_03v3 ad=0.139p pd=1.215u as=0.2362p ps=2.03u w=0.32u l=0.28u
X977 RBL[28] a_4555_3801# A[3] VDD pfet_03v3 ad=0.2082p pd=1.84u as=0.2024p ps=1.8u w=0.44u l=0.28u
X978 VDD a_2098_6499# a_2067_5993# VDD pfet_03v3 ad=0.1496p pd=1.12u as=0.1936p ps=1.76u w=0.44u l=0.28u
X979 VDD a_2098_7595# a_2067_7089# VDD pfet_03v3 ad=0.1496p pd=1.12u as=0.1936p ps=1.76u w=0.44u l=0.28u
X980 a_5830_25131# a_5799_24625# VDD VDD pfet_03v3 ad=0.1936p pd=1.76u as=0.1496p ps=1.12u w=0.44u l=0.28u
X981 RBL[72] a_2067_10377# A[9] VDD pfet_03v3 ad=0.2082p pd=1.84u as=0.2024p ps=1.8u w=0.44u l=0.28u
X982 a_2720_2115# WL[1] WBL[1] VSS nfet_03v3 ad=0.1397p pd=1.22u as=0.1706p ps=1.7u w=0.32u l=0.28u
X983 VSS a_2720_8691# a_2689_8185# VSS nfet_03v3 ad=0.1108p pd=1.1u as=0.139p ps=1.215u w=0.22u l=0.28u
X984 a_2689_21337# WL[19] WBLB[1] VSS nfet_03v3 ad=0.139p pd=1.215u as=0.2362p ps=2.03u w=0.32u l=0.28u
X985 VSS a_5830_3211# a_5799_2705# VSS nfet_03v3 ad=0.1108p pd=1.1u as=0.139p ps=1.215u w=0.22u l=0.28u
X986 VSS a_5830_2115# a_5799_1609# VSS nfet_03v3 ad=0.1108p pd=1.1u as=0.139p ps=1.215u w=0.22u l=0.28u
X987 a_5830_1019# WL[0] WBL[6] VSS nfet_03v3 ad=0.1397p pd=1.22u as=0.1706p ps=1.7u w=0.32u l=0.28u
X988 VSS a_6452_9787# a_6421_9281# VSS nfet_03v3 ad=0.1108p pd=1.1u as=0.139p ps=1.215u w=0.22u l=0.28u
X989 a_2720_30611# a_2689_30105# VSS VSS nfet_03v3 ad=0.1397p pd=1.22u as=0.1108p ps=1.1u w=0.22u l=0.28u
X990 RBL[203] a_3933_27913# VSS VSS nfet_03v3 ad=0.1516p pd=1.64u as=0.1516p ps=1.64u w=0.22u l=0.28u
X991 RBL[195] a_3933_26817# VSS VSS nfet_03v3 ad=0.1516p pd=1.64u as=0.1516p ps=1.64u w=0.22u l=0.28u
X992 a_3964_5403# a_3933_4897# VSS VSS nfet_03v3 ad=0.1397p pd=1.22u as=0.1108p ps=1.1u w=0.22u l=0.28u
X993 RBL[223] a_6421_30105# A[27] VDD pfet_03v3 ad=0.2082p pd=1.84u as=0.2024p ps=1.8u w=0.44u l=0.28u
X994 a_5208_16363# WL[14] WBL[5] VSS nfet_03v3 ad=0.1397p pd=1.22u as=0.1706p ps=1.7u w=0.32u l=0.28u
X995 a_5208_17459# WL[15] WBL[5] VSS nfet_03v3 ad=0.1397p pd=1.22u as=0.1706p ps=1.7u w=0.32u l=0.28u
X996 VSS a_2720_29515# a_2689_29009# VSS nfet_03v3 ad=0.1108p pd=1.1u as=0.139p ps=1.215u w=0.22u l=0.28u
X997 a_6452_8691# a_6421_8185# VSS VSS nfet_03v3 ad=0.1397p pd=1.22u as=0.1108p ps=1.1u w=0.22u l=0.28u
X998 RBL[113] a_2689_15857# VSS VSS nfet_03v3 ad=0.1516p pd=1.64u as=0.1516p ps=1.64u w=0.22u l=0.28u
X999 RBL[121] a_2689_16953# VSS VSS nfet_03v3 ad=0.1516p pd=1.64u as=0.1516p ps=1.64u w=0.22u l=0.28u
X1000 a_3342_26227# a_3311_25721# VDD VDD pfet_03v3 ad=0.1936p pd=1.76u as=0.1496p ps=1.12u w=0.44u l=0.28u
X1001 a_3342_16363# a_3311_15857# VSS VSS nfet_03v3 ad=0.1397p pd=1.22u as=0.1108p ps=1.1u w=0.22u l=0.28u
X1002 a_3342_17459# a_3311_16953# VSS VSS nfet_03v3 ad=0.1397p pd=1.22u as=0.1108p ps=1.1u w=0.22u l=0.28u
X1003 a_5208_6499# WL[5] WBL[5] VSS nfet_03v3 ad=0.1397p pd=1.22u as=0.1706p ps=1.7u w=0.32u l=0.28u
X1004 a_5208_5403# WL[4] WBL[5] VSS nfet_03v3 ad=0.1397p pd=1.22u as=0.1706p ps=1.7u w=0.32u l=0.28u
X1005 a_3964_13075# a_3933_12569# VSS VSS nfet_03v3 ad=0.1397p pd=1.22u as=0.1108p ps=1.1u w=0.22u l=0.28u
X1006 a_3964_14171# a_3933_13665# VSS VSS nfet_03v3 ad=0.1397p pd=1.22u as=0.1108p ps=1.1u w=0.22u l=0.28u
X1007 VDD a_3964_20747# a_3933_20241# VDD pfet_03v3 ad=0.1496p pd=1.12u as=0.1936p ps=1.76u w=0.44u l=0.28u
X1008 RBL[17] a_2720_3211# A[2] VSS nfet_03v3 ad=0.1516p pd=1.64u as=0.1516p ps=1.64u w=0.22u l=0.28u
X1009 a_4586_17459# a_4555_16953# VDD VDD pfet_03v3 ad=0.1936p pd=1.76u as=0.1496p ps=1.12u w=0.44u l=0.28u
X1010 a_4586_18555# a_4555_18049# VDD VDD pfet_03v3 ad=0.1936p pd=1.76u as=0.1496p ps=1.12u w=0.44u l=0.28u
X1011 a_4586_8691# a_4555_8185# VDD VDD pfet_03v3 ad=0.1936p pd=1.76u as=0.1496p ps=1.12u w=0.44u l=0.28u
X1012 a_4586_9787# a_4555_9281# VDD VDD pfet_03v3 ad=0.1936p pd=1.76u as=0.1496p ps=1.12u w=0.44u l=0.28u
X1013 RBL[94] a_5799_12569# VSS VSS nfet_03v3 ad=0.1516p pd=1.64u as=0.1516p ps=1.64u w=0.22u l=0.28u
X1014 a_5830_25131# a_5799_24625# VSS VSS nfet_03v3 ad=0.1397p pd=1.22u as=0.1108p ps=1.1u w=0.22u l=0.28u
X1015 RBL[26] a_3311_3801# VSS VSS nfet_03v3 ad=0.1516p pd=1.64u as=0.1516p ps=1.64u w=0.22u l=0.28u
X1016 a_5830_32803# a_5799_32297# VDD VDD pfet_03v3 ad=0.1936p pd=1.76u as=0.1496p ps=1.12u w=0.44u l=0.28u
X1017 a_6452_1019# WL[0] WBL[7] VSS nfet_03v3 ad=0.1397p pd=1.22u as=0.1706p ps=1.7u w=0.32u l=0.28u
X1018 a_5830_24035# a_5799_23529# VSS VSS nfet_03v3 ad=0.1397p pd=1.22u as=0.1108p ps=1.1u w=0.22u l=0.28u
X1019 RBL[97] a_2689_13665# A[12] VDD pfet_03v3 ad=0.2082p pd=1.84u as=0.2024p ps=1.8u w=0.44u l=0.28u
X1020 RBL[239] a_6421_32297# VSS VSS nfet_03v3 ad=0.1516p pd=1.64u as=0.1516p ps=1.64u w=0.22u l=0.28u
X1021 RBL[176] a_2067_24625# A[22] VDD pfet_03v3 ad=0.2082p pd=1.84u as=0.2024p ps=1.8u w=0.44u l=0.28u
X1022 a_5208_17459# a_5177_16953# VDD VDD pfet_03v3 ad=0.1936p pd=1.76u as=0.1496p ps=1.12u w=0.44u l=0.28u
X1023 a_5208_18555# a_5177_18049# VDD VDD pfet_03v3 ad=0.1936p pd=1.76u as=0.1496p ps=1.12u w=0.44u l=0.28u
X1024 RBL[219] a_3964_30611# A[27] VSS nfet_03v3 ad=0.1516p pd=1.64u as=0.1516p ps=1.64u w=0.22u l=0.28u
X1025 a_6421_18049# WL[16] WBLB[7] VSS nfet_03v3 ad=0.139p pd=1.215u as=0.2362p ps=2.03u w=0.32u l=0.28u
X1026 RBL[213] a_5177_29009# VSS VSS nfet_03v3 ad=0.1516p pd=1.64u as=0.1516p ps=1.64u w=0.22u l=0.28u
X1027 a_2098_28419# WL[25] WBL[0] VSS nfet_03v3 ad=0.1397p pd=1.22u as=0.1706p ps=1.7u w=0.32u l=0.28u
X1028 a_2098_27323# WL[24] WBL[0] VSS nfet_03v3 ad=0.1397p pd=1.22u as=0.1706p ps=1.7u w=0.32u l=0.28u
X1029 VSS a_2098_33899# a_2067_33393# VSS nfet_03v3 ad=0.1108p pd=1.1u as=0.139p ps=1.215u w=0.22u l=0.28u
X1030 VSS a_2098_32803# a_2067_32297# VSS nfet_03v3 ad=0.1108p pd=1.1u as=0.139p ps=1.215u w=0.22u l=0.28u
X1031 a_6452_34995# a_6421_34489# VDD VDD pfet_03v3 ad=0.1936p pd=1.76u as=0.1496p ps=1.12u w=0.44u l=0.28u
X1032 a_6452_33899# a_6421_33393# VDD VDD pfet_03v3 ad=0.1936p pd=1.76u as=0.1496p ps=1.12u w=0.44u l=0.28u
X1033 a_6452_26227# a_6421_25721# VSS VSS nfet_03v3 ad=0.1397p pd=1.22u as=0.1108p ps=1.1u w=0.22u l=0.28u
X1034 RBL[145] a_2720_20747# A[18] VSS nfet_03v3 ad=0.1516p pd=1.64u as=0.1516p ps=1.64u w=0.22u l=0.28u
X1035 RBL[251] a_3933_34489# a_4177_35171# VSS nfet_03v3 ad=0.1516p pd=1.64u as=0.1516p ps=1.64u w=0.22u l=0.28u
X1036 RBL[26] a_3342_4307# A[3] VSS nfet_03v3 ad=0.1516p pd=1.64u as=0.1516p ps=1.64u w=0.22u l=0.28u
X1037 a_5208_24035# WL[21] WBL[5] VSS nfet_03v3 ad=0.1397p pd=1.22u as=0.1706p ps=1.7u w=0.32u l=0.28u
X1038 VSS a_5208_30611# a_5177_30105# VSS nfet_03v3 ad=0.1108p pd=1.1u as=0.139p ps=1.215u w=0.22u l=0.28u
X1039 VSS a_4586_9787# a_4555_9281# VSS nfet_03v3 ad=0.1108p pd=1.1u as=0.139p ps=1.215u w=0.22u l=0.28u
X1040 a_4586_8691# a_4555_8185# VSS VSS nfet_03v3 ad=0.1397p pd=1.22u as=0.1108p ps=1.1u w=0.22u l=0.28u
X1041 VDD a_2720_16363# a_2689_15857# VDD pfet_03v3 ad=0.1496p pd=1.12u as=0.1936p ps=1.76u w=0.44u l=0.28u
X1042 a_6452_19651# WL[17] WBL[7] VSS nfet_03v3 ad=0.1397p pd=1.22u as=0.1706p ps=1.7u w=0.32u l=0.28u
X1043 RBL[136] a_2098_19651# A[17] VSS nfet_03v3 ad=0.1516p pd=1.64u as=0.1516p ps=1.64u w=0.22u l=0.28u
X1044 a_2098_29515# a_2067_29009# VDD VDD pfet_03v3 ad=0.1936p pd=1.76u as=0.1496p ps=1.12u w=0.44u l=0.28u
X1045 a_2098_28419# a_2067_27913# VDD VDD pfet_03v3 ad=0.1936p pd=1.76u as=0.1496p ps=1.12u w=0.44u l=0.28u
X1046 RBL[37] a_5177_4897# A[4] VDD pfet_03v3 ad=0.2082p pd=1.84u as=0.2024p ps=1.8u w=0.44u l=0.28u
X1047 RBL[29] a_5177_3801# A[3] VDD pfet_03v3 ad=0.2082p pd=1.84u as=0.2024p ps=1.8u w=0.44u l=0.28u
X1048 a_3311_29009# WL[26] WBLB[2] VSS nfet_03v3 ad=0.139p pd=1.215u as=0.2362p ps=2.03u w=0.32u l=0.28u
X1049 a_3933_31201# WL[28] WBLB[3] VSS nfet_03v3 ad=0.139p pd=1.215u as=0.2362p ps=2.03u w=0.32u l=0.28u
X1050 VSS a_3342_34995# a_3311_34489# VSS nfet_03v3 ad=0.1108p pd=1.1u as=0.139p ps=1.215u w=0.22u l=0.28u
X1051 RBL[54] a_5830_7595# A[6] VSS nfet_03v3 ad=0.1516p pd=1.64u as=0.1516p ps=1.64u w=0.22u l=0.28u
X1052 a_6421_25721# WL[23] WBLB[7] VSS nfet_03v3 ad=0.139p pd=1.215u as=0.2362p ps=2.03u w=0.32u l=0.28u
X1053 a_6421_24625# WL[22] WBLB[7] VSS nfet_03v3 ad=0.139p pd=1.215u as=0.2362p ps=2.03u w=0.32u l=0.28u
X1054 a_5830_10883# a_5799_10377# VDD VDD pfet_03v3 ad=0.1936p pd=1.76u as=0.1496p ps=1.12u w=0.44u l=0.28u
X1055 VSS a_5830_34995# a_5799_34489# VSS nfet_03v3 ad=0.1108p pd=1.1u as=0.139p ps=1.215u w=0.22u l=0.28u
X1056 VSS a_6452_31707# a_6421_31201# VSS nfet_03v3 ad=0.1108p pd=1.1u as=0.139p ps=1.215u w=0.22u l=0.28u
X1057 RBL[220] a_4555_30105# A[27] VDD pfet_03v3 ad=0.2082p pd=1.84u as=0.2024p ps=1.8u w=0.44u l=0.28u
X1058 VDD a_3964_2115# a_3933_1609# VDD pfet_03v3 ad=0.1496p pd=1.12u as=0.1936p ps=1.76u w=0.44u l=0.28u
X1059 RBL[240] a_2067_33393# A[30] VDD pfet_03v3 ad=0.2082p pd=1.84u as=0.2024p ps=1.8u w=0.44u l=0.28u
X1060 RBL[161] a_2689_22433# A[20] VDD pfet_03v3 ad=0.2082p pd=1.84u as=0.2024p ps=1.8u w=0.44u l=0.28u
X1061 RBL[213] a_5208_29515# A[26] VSS nfet_03v3 ad=0.1516p pd=1.64u as=0.1516p ps=1.64u w=0.22u l=0.28u
X1062 VDD a_2098_20747# a_2067_20241# VDD pfet_03v3 ad=0.1496p pd=1.12u as=0.1936p ps=1.76u w=0.44u l=0.28u
X1063 a_6452_11979# a_6421_11473# VDD VDD pfet_03v3 ad=0.1936p pd=1.76u as=0.1496p ps=1.12u w=0.44u l=0.28u
X1064 a_6452_13075# a_6421_12569# VDD VDD pfet_03v3 ad=0.1936p pd=1.76u as=0.1496p ps=1.12u w=0.44u l=0.28u
X1065 RBL[91] a_3933_12569# VSS VSS nfet_03v3 ad=0.1516p pd=1.64u as=0.1516p ps=1.64u w=0.22u l=0.28u
X1066 RBL[221] a_5177_30105# A[27] VDD pfet_03v3 ad=0.2082p pd=1.84u as=0.2024p ps=1.8u w=0.44u l=0.28u
X1067 a_3964_16363# WL[14] WBL[3] VSS nfet_03v3 ad=0.1397p pd=1.22u as=0.1706p ps=1.7u w=0.32u l=0.28u
X1068 a_3964_17459# WL[15] WBL[3] VSS nfet_03v3 ad=0.1397p pd=1.22u as=0.1706p ps=1.7u w=0.32u l=0.28u
X1069 a_5208_8691# a_5177_8185# VDD VDD pfet_03v3 ad=0.1936p pd=1.76u as=0.1496p ps=1.12u w=0.44u l=0.28u
X1070 a_5208_9787# a_5177_9281# VDD VDD pfet_03v3 ad=0.1936p pd=1.76u as=0.1496p ps=1.12u w=0.44u l=0.28u
X1071 RBL[37] a_5208_5403# A[4] VSS nfet_03v3 ad=0.1516p pd=1.64u as=0.1516p ps=1.64u w=0.22u l=0.28u
X1072 RBL[45] a_5208_6499# A[5] VSS nfet_03v3 ad=0.1516p pd=1.64u as=0.1516p ps=1.64u w=0.22u l=0.28u
X1073 a_5830_1019# a_5799_513# VSS VSS nfet_03v3 ad=0.1397p pd=1.22u as=0.1108p ps=1.1u w=0.22u l=0.28u
X1074 RBL[9] a_2689_1609# VSS VSS nfet_03v3 ad=0.1516p pd=1.64u as=0.1516p ps=1.64u w=0.22u l=0.28u
X1075 VDD a_2720_3211# a_2689_2705# VDD pfet_03v3 ad=0.1496p pd=1.12u as=0.1936p ps=1.76u w=0.44u l=0.28u
X1076 RBL[135] a_6452_18555# A[16] VSS nfet_03v3 ad=0.1516p pd=1.64u as=0.1516p ps=1.64u w=0.22u l=0.28u
X1077 a_3342_17459# a_3311_16953# VDD VDD pfet_03v3 ad=0.1936p pd=1.76u as=0.1496p ps=1.12u w=0.44u l=0.28u
X1078 a_3342_18555# a_3311_18049# VDD VDD pfet_03v3 ad=0.1936p pd=1.76u as=0.1496p ps=1.12u w=0.44u l=0.28u
X1079 a_3964_15267# a_3933_14761# VDD VDD pfet_03v3 ad=0.1936p pd=1.76u as=0.1496p ps=1.12u w=0.44u l=0.28u
X1080 RBL[34] a_3311_4897# A[4] VDD pfet_03v3 ad=0.2082p pd=1.84u as=0.2024p ps=1.8u w=0.44u l=0.28u
X1081 RBL[233] a_2689_32297# VSS VSS nfet_03v3 ad=0.1516p pd=1.64u as=0.1516p ps=1.64u w=0.22u l=0.28u
X1082 RBL[210] a_3311_29009# VSS VSS nfet_03v3 ad=0.1516p pd=1.64u as=0.1516p ps=1.64u w=0.22u l=0.28u
X1083 RBL[26] a_3311_3801# A[3] VDD pfet_03v3 ad=0.2082p pd=1.84u as=0.2024p ps=1.8u w=0.44u l=0.28u
X1084 a_4586_18555# WL[16] WBL[4] VSS nfet_03v3 ad=0.1397p pd=1.22u as=0.1706p ps=1.7u w=0.32u l=0.28u
X1085 a_4586_26227# a_4555_25721# VSS VSS nfet_03v3 ad=0.1397p pd=1.22u as=0.1108p ps=1.1u w=0.22u l=0.28u
X1086 a_2720_2115# a_2689_1609# VDD VDD pfet_03v3 ad=0.1936p pd=1.76u as=0.1496p ps=1.12u w=0.44u l=0.28u
X1087 a_4586_34995# a_4555_34489# VDD VDD pfet_03v3 ad=0.1936p pd=1.76u as=0.1496p ps=1.12u w=0.44u l=0.28u
X1088 a_4586_33899# a_4555_33393# VDD VDD pfet_03v3 ad=0.1936p pd=1.76u as=0.1496p ps=1.12u w=0.44u l=0.28u
X1089 RBL[51] a_3964_7595# A[6] VSS nfet_03v3 ad=0.1516p pd=1.64u as=0.1516p ps=1.64u w=0.22u l=0.28u
X1090 RBL[128] a_2067_18049# VSS VSS nfet_03v3 ad=0.1516p pd=1.64u as=0.1516p ps=1.64u w=0.22u l=0.28u
X1091 RBL[191] a_6421_25721# VSS VSS nfet_03v3 ad=0.1516p pd=1.64u as=0.1516p ps=1.64u w=0.22u l=0.28u
X1092 RBL[183] a_6421_24625# VSS VSS nfet_03v3 ad=0.1516p pd=1.64u as=0.1516p ps=1.64u w=0.22u l=0.28u
X1093 a_2067_513# WL[0] WBLB[0] VSS nfet_03v3 ad=0.139p pd=1.215u as=0.2362p ps=2.03u w=0.32u l=0.28u
X1094 a_2720_34995# WL[31] WBL[1] VSS nfet_03v3 ad=0.1397p pd=1.22u as=0.1706p ps=1.7u w=0.32u l=0.28u
X1095 VDD a_2720_25131# a_2689_24625# VDD pfet_03v3 ad=0.1496p pd=1.12u as=0.1936p ps=1.76u w=0.44u l=0.28u
X1096 a_6452_3211# a_6421_2705# VDD VDD pfet_03v3 ad=0.1936p pd=1.76u as=0.1496p ps=1.12u w=0.44u l=0.28u
X1097 VDD a_3342_21843# a_3311_21337# VDD pfet_03v3 ad=0.1496p pd=1.12u as=0.1936p ps=1.76u w=0.44u l=0.28u
X1098 RBL[5] a_5177_513# A[0] VDD pfet_03v3 ad=0.2082p pd=1.84u as=0.2024p ps=1.8u w=0.44u l=0.28u
X1099 a_5177_18049# WL[16] WBLB[5] VSS nfet_03v3 ad=0.139p pd=1.215u as=0.2362p ps=2.03u w=0.32u l=0.28u
X1100 VSS a_3964_7595# a_3933_7089# VSS nfet_03v3 ad=0.1108p pd=1.1u as=0.139p ps=1.215u w=0.22u l=0.28u
X1101 RBL[132] a_4555_18049# VSS VSS nfet_03v3 ad=0.1516p pd=1.64u as=0.1516p ps=1.64u w=0.22u l=0.28u
X1102 RBL[101] a_5177_13665# VSS VSS nfet_03v3 ad=0.1516p pd=1.64u as=0.1516p ps=1.64u w=0.22u l=0.28u
X1103 RBL[109] a_5177_14761# VSS VSS nfet_03v3 ad=0.1516p pd=1.64u as=0.1516p ps=1.64u w=0.22u l=0.28u
X1104 a_2098_19651# WL[17] WBL[0] VSS nfet_03v3 ad=0.1397p pd=1.22u as=0.1706p ps=1.7u w=0.32u l=0.28u
X1105 a_5830_31707# WL[28] WBL[6] VSS nfet_03v3 ad=0.1397p pd=1.22u as=0.1706p ps=1.7u w=0.32u l=0.28u
X1106 VDD a_5830_21843# a_5799_21337# VDD pfet_03v3 ad=0.1496p pd=1.12u as=0.1936p ps=1.76u w=0.44u l=0.28u
X1107 a_5208_34995# a_5177_34489# VDD VDD pfet_03v3 ad=0.1936p pd=1.76u as=0.1496p ps=1.12u w=0.44u l=0.28u
X1108 a_5208_33899# a_5177_33393# VDD VDD pfet_03v3 ad=0.1936p pd=1.76u as=0.1496p ps=1.12u w=0.44u l=0.28u
X1109 a_5208_26227# a_5177_25721# VSS VSS nfet_03v3 ad=0.1397p pd=1.22u as=0.1108p ps=1.1u w=0.22u l=0.28u
X1110 a_6452_11979# a_6421_11473# VSS VSS nfet_03v3 ad=0.1397p pd=1.22u as=0.1108p ps=1.1u w=0.22u l=0.28u
X1111 a_6452_10883# a_6421_10377# VSS VSS nfet_03v3 ad=0.1397p pd=1.22u as=0.1108p ps=1.1u w=0.22u l=0.28u
X1112 VDD a_2098_2115# a_2067_1609# VDD pfet_03v3 ad=0.1496p pd=1.12u as=0.1936p ps=1.76u w=0.44u l=0.28u
X1113 a_3964_24035# WL[21] WBL[3] VSS nfet_03v3 ad=0.1397p pd=1.22u as=0.1706p ps=1.7u w=0.32u l=0.28u
X1114 a_3964_6499# a_3933_5993# VSS VSS nfet_03v3 ad=0.1397p pd=1.22u as=0.1108p ps=1.1u w=0.22u l=0.28u
X1115 a_5208_8691# a_5177_8185# VSS VSS nfet_03v3 ad=0.1397p pd=1.22u as=0.1108p ps=1.1u w=0.22u l=0.28u
X1116 a_3964_6499# WL[5] WBL[3] VSS nfet_03v3 ad=0.1397p pd=1.22u as=0.1706p ps=1.7u w=0.32u l=0.28u
X1117 a_3964_5403# WL[4] WBL[3] VSS nfet_03v3 ad=0.1397p pd=1.22u as=0.1706p ps=1.7u w=0.32u l=0.28u
X1118 a_3342_9787# a_3311_9281# VDD VDD pfet_03v3 ad=0.1936p pd=1.76u as=0.1496p ps=1.12u w=0.44u l=0.28u
X1119 a_3342_8691# a_3311_8185# VDD VDD pfet_03v3 ad=0.1936p pd=1.76u as=0.1496p ps=1.12u w=0.44u l=0.28u
X1120 VSS a_4586_31707# a_4555_31201# VSS nfet_03v3 ad=0.1108p pd=1.1u as=0.139p ps=1.215u w=0.22u l=0.28u
X1121 a_4586_26227# WL[23] WBL[4] VSS nfet_03v3 ad=0.1397p pd=1.22u as=0.1706p ps=1.7u w=0.32u l=0.28u
X1122 a_4586_25131# WL[22] WBL[4] VSS nfet_03v3 ad=0.1397p pd=1.22u as=0.1706p ps=1.7u w=0.32u l=0.28u
X1123 a_3311_7089# WL[6] WBLB[2] VSS nfet_03v3 ad=0.139p pd=1.215u as=0.2362p ps=2.03u w=0.32u l=0.28u
X1124 a_2067_29009# WL[26] WBLB[0] VSS nfet_03v3 ad=0.139p pd=1.215u as=0.2362p ps=2.03u w=0.32u l=0.28u
X1125 a_2720_7595# a_2689_7089# VSS VSS nfet_03v3 ad=0.1397p pd=1.22u as=0.1108p ps=1.1u w=0.22u l=0.28u
X1126 RBL[38] a_5799_4897# VSS VSS nfet_03v3 ad=0.1516p pd=1.64u as=0.1516p ps=1.64u w=0.22u l=0.28u
X1127 RBL[46] a_5799_5993# VSS VSS nfet_03v3 ad=0.1516p pd=1.64u as=0.1516p ps=1.64u w=0.22u l=0.28u
X1128 RBL[247] a_6421_33393# VSS VSS nfet_03v3 ad=0.1516p pd=1.64u as=0.1516p ps=1.64u w=0.22u l=0.28u
X1129 VDD a_2720_32803# a_2689_32297# VDD pfet_03v3 ad=0.1496p pd=1.12u as=0.1936p ps=1.76u w=0.44u l=0.28u
X1130 VSS a_2720_25131# a_2689_24625# VSS nfet_03v3 ad=0.1108p pd=1.1u as=0.139p ps=1.215u w=0.22u l=0.28u
X1131 VSS a_2720_24035# a_2689_23529# VSS nfet_03v3 ad=0.1108p pd=1.1u as=0.139p ps=1.215u w=0.22u l=0.28u
X1132 VSS a_3342_20747# a_3311_20241# VSS nfet_03v3 ad=0.1108p pd=1.1u as=0.139p ps=1.215u w=0.22u l=0.28u
X1133 a_5177_25721# WL[23] WBLB[5] VSS nfet_03v3 ad=0.139p pd=1.215u as=0.2362p ps=2.03u w=0.32u l=0.28u
X1134 a_5177_24625# WL[22] WBLB[5] VSS nfet_03v3 ad=0.139p pd=1.215u as=0.2362p ps=2.03u w=0.32u l=0.28u
X1135 a_4586_11979# a_4555_11473# VDD VDD pfet_03v3 ad=0.1936p pd=1.76u as=0.1496p ps=1.12u w=0.44u l=0.28u
X1136 a_4586_13075# a_4555_12569# VDD VDD pfet_03v3 ad=0.1936p pd=1.76u as=0.1496p ps=1.12u w=0.44u l=0.28u
X1137 a_3964_24035# a_3933_23529# VDD VDD pfet_03v3 ad=0.1936p pd=1.76u as=0.1496p ps=1.12u w=0.44u l=0.28u
X1138 a_4586_3211# a_4555_2705# VDD VDD pfet_03v3 ad=0.1936p pd=1.76u as=0.1496p ps=1.12u w=0.44u l=0.28u
X1139 VSS a_5830_20747# a_5799_20241# VSS nfet_03v3 ad=0.1108p pd=1.1u as=0.139p ps=1.215u w=0.22u l=0.28u
X1140 a_3964_22939# a_3933_22433# VDD VDD pfet_03v3 ad=0.1936p pd=1.76u as=0.1496p ps=1.12u w=0.44u l=0.28u
X1141 RBL[218] a_3311_30105# A[27] VDD pfet_03v3 ad=0.2082p pd=1.84u as=0.2024p ps=1.8u w=0.44u l=0.28u
X1142 a_2720_13075# WL[11] WBL[1] VSS nfet_03v3 ad=0.1397p pd=1.22u as=0.1706p ps=1.7u w=0.32u l=0.28u
X1143 VSS a_2098_7595# a_2067_7089# VSS nfet_03v3 ad=0.1108p pd=1.1u as=0.139p ps=1.215u w=0.22u l=0.28u
X1144 RBL[52] a_4555_7089# VSS VSS nfet_03v3 ad=0.1516p pd=1.64u as=0.1516p ps=1.64u w=0.22u l=0.28u
X1145 RBL[132] a_4586_18555# A[16] VSS nfet_03v3 ad=0.1516p pd=1.64u as=0.1516p ps=1.64u w=0.22u l=0.28u
X1146 RBL[101] a_5208_14171# A[12] VSS nfet_03v3 ad=0.1516p pd=1.64u as=0.1516p ps=1.64u w=0.22u l=0.28u
X1147 RBL[109] a_5208_15267# A[13] VSS nfet_03v3 ad=0.1516p pd=1.64u as=0.1516p ps=1.64u w=0.22u l=0.28u
X1148 a_5799_27913# WL[25] WBLB[6] VSS nfet_03v3 ad=0.139p pd=1.215u as=0.2362p ps=2.03u w=0.32u l=0.28u
X1149 a_5799_26817# WL[24] WBLB[6] VSS nfet_03v3 ad=0.139p pd=1.215u as=0.2362p ps=2.03u w=0.32u l=0.28u
X1150 a_5208_11979# a_5177_11473# VDD VDD pfet_03v3 ad=0.1936p pd=1.76u as=0.1496p ps=1.12u w=0.44u l=0.28u
X1151 a_5208_13075# a_5177_12569# VDD VDD pfet_03v3 ad=0.1936p pd=1.76u as=0.1496p ps=1.12u w=0.44u l=0.28u
X1152 a_3342_8691# a_3311_8185# VSS VSS nfet_03v3 ad=0.1397p pd=1.22u as=0.1108p ps=1.1u w=0.22u l=0.28u
X1153 a_5799_513# WL[0] WBLB[6] VSS nfet_03v3 ad=0.139p pd=1.215u as=0.2362p ps=2.03u w=0.32u l=0.28u
X1154 a_5830_7595# WL[6] WBL[6] VSS nfet_03v3 ad=0.1397p pd=1.22u as=0.1706p ps=1.7u w=0.32u l=0.28u
X1155 RBL[185] a_2689_25721# VSS VSS nfet_03v3 ad=0.1516p pd=1.64u as=0.1516p ps=1.64u w=0.22u l=0.28u
X1156 RBL[177] a_2689_24625# VSS VSS nfet_03v3 ad=0.1516p pd=1.64u as=0.1516p ps=1.64u w=0.22u l=0.28u
X1157 RBL[98] a_3311_13665# VSS VSS nfet_03v3 ad=0.1516p pd=1.64u as=0.1516p ps=1.64u w=0.22u l=0.28u
X1158 RBL[106] a_3311_14761# VSS VSS nfet_03v3 ad=0.1516p pd=1.64u as=0.1516p ps=1.64u w=0.22u l=0.28u
X1159 a_3342_18555# WL[16] WBL[2] VSS nfet_03v3 ad=0.1397p pd=1.22u as=0.1706p ps=1.7u w=0.32u l=0.28u
X1160 a_3342_26227# a_3311_25721# VSS VSS nfet_03v3 ad=0.1397p pd=1.22u as=0.1108p ps=1.1u w=0.22u l=0.28u
X1161 RBL[35] a_3933_4897# VSS VSS nfet_03v3 ad=0.1516p pd=1.64u as=0.1516p ps=1.64u w=0.22u l=0.28u
X1162 RBL[43] a_3933_5993# VSS VSS nfet_03v3 ad=0.1516p pd=1.64u as=0.1516p ps=1.64u w=0.22u l=0.28u
X1163 a_3342_34995# a_3311_34489# VDD VDD pfet_03v3 ad=0.1936p pd=1.76u as=0.1496p ps=1.12u w=0.44u l=0.28u
X1164 a_3342_33899# a_3311_33393# VDD VDD pfet_03v3 ad=0.1936p pd=1.76u as=0.1496p ps=1.12u w=0.44u l=0.28u
X1165 a_4586_10883# a_4555_10377# VSS VSS nfet_03v3 ad=0.1397p pd=1.22u as=0.1108p ps=1.1u w=0.22u l=0.28u
X1166 a_4586_11979# a_4555_11473# VSS VSS nfet_03v3 ad=0.1397p pd=1.22u as=0.1108p ps=1.1u w=0.22u l=0.28u
X1167 a_3964_31707# a_3933_31201# VDD VDD pfet_03v3 ad=0.1936p pd=1.76u as=0.1496p ps=1.12u w=0.44u l=0.28u
X1168 a_3964_30611# a_3933_30105# VDD VDD pfet_03v3 ad=0.1936p pd=1.76u as=0.1496p ps=1.12u w=0.44u l=0.28u
X1169 a_3964_21843# a_3933_21337# VSS VSS nfet_03v3 ad=0.1397p pd=1.22u as=0.1108p ps=1.1u w=0.22u l=0.28u
X1170 a_3964_22939# a_3933_22433# VSS VSS nfet_03v3 ad=0.1397p pd=1.22u as=0.1108p ps=1.1u w=0.22u l=0.28u
X1171 VDD a_2720_10883# a_2689_10377# VDD pfet_03v3 ad=0.1496p pd=1.12u as=0.1936p ps=1.76u w=0.44u l=0.28u
X1172 RBL[79] a_6421_10377# VSS VSS nfet_03v3 ad=0.1516p pd=1.64u as=0.1516p ps=1.64u w=0.22u l=0.28u
X1173 RBL[87] a_6421_11473# VSS VSS nfet_03v3 ad=0.1516p pd=1.64u as=0.1516p ps=1.64u w=0.22u l=0.28u
X1174 RBL[142] a_5830_19651# A[17] VSS nfet_03v3 ad=0.1516p pd=1.64u as=0.1516p ps=1.64u w=0.22u l=0.28u
X1175 RBL[166] a_5799_22433# VSS VSS nfet_03v3 ad=0.1516p pd=1.64u as=0.1516p ps=1.64u w=0.22u l=0.28u
X1176 a_6452_14171# WL[12] WBL[7] VSS nfet_03v3 ad=0.1397p pd=1.22u as=0.1706p ps=1.7u w=0.32u l=0.28u
X1177 a_6452_15267# WL[13] WBL[7] VSS nfet_03v3 ad=0.1397p pd=1.22u as=0.1706p ps=1.7u w=0.32u l=0.28u
X1178 a_2098_15267# a_2067_14761# VSS VSS nfet_03v3 ad=0.1397p pd=1.22u as=0.1108p ps=1.1u w=0.22u l=0.28u
X1179 RBL[158] a_5799_21337# VSS VSS nfet_03v3 ad=0.1516p pd=1.64u as=0.1516p ps=1.64u w=0.22u l=0.28u
X1180 a_2720_19651# a_2689_19145# VDD VDD pfet_03v3 ad=0.1936p pd=1.76u as=0.1496p ps=1.12u w=0.44u l=0.28u
X1181 a_5830_33899# a_5799_33393# VSS VSS nfet_03v3 ad=0.1397p pd=1.22u as=0.1108p ps=1.1u w=0.22u l=0.28u
X1182 a_5830_32803# a_5799_32297# VSS VSS nfet_03v3 ad=0.1397p pd=1.22u as=0.1108p ps=1.1u w=0.22u l=0.28u
X1183 a_5208_11979# a_5177_11473# VSS VSS nfet_03v3 ad=0.1397p pd=1.22u as=0.1108p ps=1.1u w=0.22u l=0.28u
X1184 a_5208_10883# a_5177_10377# VSS VSS nfet_03v3 ad=0.1397p pd=1.22u as=0.1108p ps=1.1u w=0.22u l=0.28u
X1185 RBL[229] a_5177_31201# VSS VSS nfet_03v3 ad=0.1516p pd=1.64u as=0.1516p ps=1.64u w=0.22u l=0.28u
X1186 RBL[63] a_6421_8185# VSS VSS nfet_03v3 ad=0.1516p pd=1.64u as=0.1516p ps=1.64u w=0.22u l=0.28u
X1187 RBL[71] a_6421_9281# VSS VSS nfet_03v3 ad=0.1516p pd=1.64u as=0.1516p ps=1.64u w=0.22u l=0.28u
X1188 a_6452_34995# a_6421_34489# VSS VSS nfet_03v3 ad=0.1397p pd=1.22u as=0.1108p ps=1.1u w=0.22u l=0.28u
X1189 VDD a_2720_4307# a_2689_3801# VDD pfet_03v3 ad=0.1496p pd=1.12u as=0.1936p ps=1.76u w=0.44u l=0.28u
X1190 a_5208_33899# WL[30] WBL[5] VSS nfet_03v3 ad=0.1397p pd=1.22u as=0.1706p ps=1.7u w=0.32u l=0.28u
X1191 a_5208_32803# WL[29] WBL[5] VSS nfet_03v3 ad=0.1397p pd=1.22u as=0.1706p ps=1.7u w=0.32u l=0.28u
X1192 RBL[241] a_2689_33393# VSS VSS nfet_03v3 ad=0.1516p pd=1.64u as=0.1516p ps=1.64u w=0.22u l=0.28u
X1193 RBL[126] a_5799_16953# A[15] VDD pfet_03v3 ad=0.2082p pd=1.84u as=0.2024p ps=1.8u w=0.44u l=0.28u
X1194 a_3342_26227# WL[23] WBL[2] VSS nfet_03v3 ad=0.1397p pd=1.22u as=0.1706p ps=1.7u w=0.32u l=0.28u
X1195 a_3342_25131# WL[22] WBL[2] VSS nfet_03v3 ad=0.1397p pd=1.22u as=0.1706p ps=1.7u w=0.32u l=0.28u
X1196 VDD a_6452_5403# a_6421_4897# VDD pfet_03v3 ad=0.1496p pd=1.12u as=0.1936p ps=1.76u w=0.44u l=0.28u
X1197 a_3964_1019# WL[0] WBL[3] VSS nfet_03v3 ad=0.1397p pd=1.22u as=0.1706p ps=1.7u w=0.32u l=0.28u
X1198 RBL[46] a_5799_5993# A[5] VDD pfet_03v3 ad=0.2082p pd=1.84u as=0.2024p ps=1.8u w=0.44u l=0.28u
X1199 a_5208_3211# a_5177_2705# VDD VDD pfet_03v3 ad=0.1936p pd=1.76u as=0.1496p ps=1.12u w=0.44u l=0.28u
X1200 a_2689_513# WL[0] WBLB[1] VSS nfet_03v3 ad=0.139p pd=1.215u as=0.2362p ps=2.03u w=0.32u l=0.28u
X1201 RBL[63] a_6452_8691# A[7] VSS nfet_03v3 ad=0.1516p pd=1.64u as=0.1516p ps=1.64u w=0.22u l=0.28u
X1202 RBL[71] a_6452_9787# A[8] VSS nfet_03v3 ad=0.1516p pd=1.64u as=0.1516p ps=1.64u w=0.22u l=0.28u
X1203 a_6452_4307# a_6421_3801# VDD VDD pfet_03v3 ad=0.1936p pd=1.76u as=0.1496p ps=1.12u w=0.44u l=0.28u
X1204 a_2720_18555# a_2689_18049# VSS VSS nfet_03v3 ad=0.1397p pd=1.22u as=0.1108p ps=1.1u w=0.22u l=0.28u
X1205 a_2720_19651# a_2689_19145# VSS VSS nfet_03v3 ad=0.1397p pd=1.22u as=0.1108p ps=1.1u w=0.22u l=0.28u
X1206 a_6452_22939# WL[20] WBL[7] VSS nfet_03v3 ad=0.1397p pd=1.22u as=0.1706p ps=1.7u w=0.32u l=0.28u
X1207 RBL[208] a_2098_29515# A[26] VSS nfet_03v3 ad=0.1516p pd=1.64u as=0.1516p ps=1.64u w=0.22u l=0.28u
X1208 a_2098_29515# a_2067_29009# VSS VSS nfet_03v3 ad=0.1397p pd=1.22u as=0.1108p ps=1.1u w=0.22u l=0.28u
X1209 a_2720_27323# a_2689_26817# VDD VDD pfet_03v3 ad=0.1936p pd=1.76u as=0.1496p ps=1.12u w=0.44u l=0.28u
X1210 a_3933_8185# WL[7] WBLB[3] VSS nfet_03v3 ad=0.139p pd=1.215u as=0.2362p ps=2.03u w=0.32u l=0.28u
X1211 a_3933_9281# WL[8] WBLB[3] VSS nfet_03v3 ad=0.139p pd=1.215u as=0.2362p ps=2.03u w=0.32u l=0.28u
X1212 a_3342_11979# a_3311_11473# VDD VDD pfet_03v3 ad=0.1936p pd=1.76u as=0.1496p ps=1.12u w=0.44u l=0.28u
X1213 a_3342_13075# a_3311_12569# VDD VDD pfet_03v3 ad=0.1936p pd=1.76u as=0.1496p ps=1.12u w=0.44u l=0.28u
X1214 RBL[135] a_6421_18049# A[16] VDD pfet_03v3 ad=0.2082p pd=1.84u as=0.2024p ps=1.8u w=0.44u l=0.28u
X1215 VDD a_5208_19651# a_5177_19145# VDD pfet_03v3 ad=0.1496p pd=1.12u as=0.1936p ps=1.76u w=0.44u l=0.28u
X1216 RBL[143] a_6421_19145# A[17] VDD pfet_03v3 ad=0.2082p pd=1.84u as=0.2024p ps=1.8u w=0.44u l=0.28u
X1217 a_6421_34489# WL[31] WBLB[7] VSS nfet_03v3 ad=0.139p pd=1.215u as=0.2362p ps=2.03u w=0.32u l=0.28u
X1218 a_5830_20747# a_5799_20241# VDD VDD pfet_03v3 ad=0.1936p pd=1.76u as=0.1496p ps=1.12u w=0.44u l=0.28u
X1219 RBL[151] a_6421_20241# VSS VSS nfet_03v3 ad=0.1516p pd=1.64u as=0.1516p ps=1.64u w=0.22u l=0.28u
X1220 RBL[222] a_5799_30105# VSS VSS nfet_03v3 ad=0.1516p pd=1.64u as=0.1516p ps=1.64u w=0.22u l=0.28u
X1221 a_4555_27913# WL[25] WBLB[4] VSS nfet_03v3 ad=0.139p pd=1.215u as=0.2362p ps=2.03u w=0.32u l=0.28u
X1222 a_4555_26817# WL[24] WBLB[4] VSS nfet_03v3 ad=0.139p pd=1.215u as=0.2362p ps=2.03u w=0.32u l=0.28u
X1223 RBL[40] a_2098_6499# A[5] VSS nfet_03v3 ad=0.1516p pd=1.64u as=0.1516p ps=1.64u w=0.22u l=0.28u
X1224 a_5799_19145# WL[17] WBLB[6] VSS nfet_03v3 ad=0.139p pd=1.215u as=0.2362p ps=2.03u w=0.32u l=0.28u
X1225 RBL[32] a_2098_5403# A[4] VSS nfet_03v3 ad=0.1516p pd=1.64u as=0.1516p ps=1.64u w=0.22u l=0.28u
X1226 RBL[32] a_2067_4897# VSS VSS nfet_03v3 ad=0.1516p pd=1.64u as=0.1516p ps=1.64u w=0.22u l=0.28u
X1227 RBL[40] a_2067_5993# VSS VSS nfet_03v3 ad=0.1516p pd=1.64u as=0.1516p ps=1.64u w=0.22u l=0.28u
X1228 VSS a_3964_3211# a_3933_2705# VSS nfet_03v3 ad=0.1108p pd=1.1u as=0.139p ps=1.215u w=0.22u l=0.28u
X1229 VSS a_3964_2115# a_3933_1609# VSS nfet_03v3 ad=0.1108p pd=1.1u as=0.139p ps=1.215u w=0.22u l=0.28u
X1230 RBL[233] a_2689_32297# A[29] VDD pfet_03v3 ad=0.2082p pd=1.84u as=0.2024p ps=1.8u w=0.44u l=0.28u
X1231 RBL[225] a_2689_31201# A[28] VDD pfet_03v3 ad=0.2082p pd=1.84u as=0.2024p ps=1.8u w=0.44u l=0.28u
X1232 RBL[229] a_5208_31707# A[28] VSS nfet_03v3 ad=0.1516p pd=1.64u as=0.1516p ps=1.64u w=0.22u l=0.28u
X1233 a_2098_14171# WL[12] WBL[0] VSS nfet_03v3 ad=0.1397p pd=1.22u as=0.1706p ps=1.7u w=0.32u l=0.28u
X1234 a_2098_15267# WL[13] WBL[0] VSS nfet_03v3 ad=0.1397p pd=1.22u as=0.1706p ps=1.7u w=0.32u l=0.28u
X1235 a_2067_7089# WL[6] WBLB[0] VSS nfet_03v3 ad=0.139p pd=1.215u as=0.2362p ps=2.03u w=0.32u l=0.28u
X1236 a_6452_21843# a_6421_21337# VDD VDD pfet_03v3 ad=0.1936p pd=1.76u as=0.1496p ps=1.12u w=0.44u l=0.28u
X1237 RBL[139] a_3964_19651# A[17] VSS nfet_03v3 ad=0.1516p pd=1.64u as=0.1516p ps=1.64u w=0.22u l=0.28u
X1238 RBL[155] a_3933_21337# VSS VSS nfet_03v3 ad=0.1516p pd=1.64u as=0.1516p ps=1.64u w=0.22u l=0.28u
X1239 RBL[163] a_3933_22433# VSS VSS nfet_03v3 ad=0.1516p pd=1.64u as=0.1516p ps=1.64u w=0.22u l=0.28u
X1240 a_5208_10883# WL[9] WBL[5] VSS nfet_03v3 ad=0.1397p pd=1.22u as=0.1706p ps=1.7u w=0.32u l=0.28u
X1241 a_5208_11979# WL[10] WBL[5] VSS nfet_03v3 ad=0.1397p pd=1.22u as=0.1706p ps=1.7u w=0.32u l=0.28u
X1242 VDD a_4586_5403# a_4555_4897# VDD pfet_03v3 ad=0.1496p pd=1.12u as=0.1936p ps=1.76u w=0.44u l=0.28u
X1243 RBL[73] a_2689_10377# VSS VSS nfet_03v3 ad=0.1516p pd=1.64u as=0.1516p ps=1.64u w=0.22u l=0.28u
X1244 RBL[81] a_2689_11473# VSS VSS nfet_03v3 ad=0.1516p pd=1.64u as=0.1516p ps=1.64u w=0.22u l=0.28u
X1245 RBL[207] a_6452_28419# A[25] VSS nfet_03v3 ad=0.1516p pd=1.64u as=0.1516p ps=1.64u w=0.22u l=0.28u
X1246 RBL[199] a_6452_27323# A[24] VSS nfet_03v3 ad=0.1516p pd=1.64u as=0.1516p ps=1.64u w=0.22u l=0.28u
X1247 VSS a_2720_4307# a_2689_3801# VSS nfet_03v3 ad=0.1108p pd=1.1u as=0.139p ps=1.215u w=0.22u l=0.28u
X1248 a_3342_3211# a_3311_2705# VDD VDD pfet_03v3 ad=0.1936p pd=1.76u as=0.1496p ps=1.12u w=0.44u l=0.28u
X1249 a_3342_10883# a_3311_10377# VSS VSS nfet_03v3 ad=0.1397p pd=1.22u as=0.1108p ps=1.1u w=0.22u l=0.28u
X1250 a_3342_11979# a_3311_11473# VSS VSS nfet_03v3 ad=0.1397p pd=1.22u as=0.1108p ps=1.1u w=0.22u l=0.28u
X1251 RBL[68] a_4586_9787# A[8] VSS nfet_03v3 ad=0.1516p pd=1.64u as=0.1516p ps=1.64u w=0.22u l=0.28u
X1252 VDD a_5208_27323# a_5177_26817# VDD pfet_03v3 ad=0.1496p pd=1.12u as=0.1936p ps=1.76u w=0.44u l=0.28u
X1253 a_6452_8691# WL[7] WBL[7] VSS nfet_03v3 ad=0.1397p pd=1.22u as=0.1706p ps=1.7u w=0.32u l=0.28u
X1254 RBL[60] a_4586_8691# A[7] VSS nfet_03v3 ad=0.1516p pd=1.64u as=0.1516p ps=1.64u w=0.22u l=0.28u
X1255 a_6452_9787# WL[8] WBL[7] VSS nfet_03v3 ad=0.1397p pd=1.22u as=0.1706p ps=1.7u w=0.32u l=0.28u
X1256 VSS a_5208_18555# a_5177_18049# VSS nfet_03v3 ad=0.1108p pd=1.1u as=0.139p ps=1.215u w=0.22u l=0.28u
X1257 VSS a_5208_19651# a_5177_19145# VSS nfet_03v3 ad=0.1108p pd=1.1u as=0.139p ps=1.215u w=0.22u l=0.28u
X1258 a_4586_4307# a_4555_3801# VDD VDD pfet_03v3 ad=0.1936p pd=1.76u as=0.1496p ps=1.12u w=0.44u l=0.28u
X1259 RBL[226] a_3311_31201# VSS VSS nfet_03v3 ad=0.1516p pd=1.64u as=0.1516p ps=1.64u w=0.22u l=0.28u
X1260 VSS a_6452_5403# a_6421_4897# VSS nfet_03v3 ad=0.1108p pd=1.1u as=0.139p ps=1.215u w=0.22u l=0.28u
X1261 a_2720_3211# a_2689_2705# VSS VSS nfet_03v3 ad=0.1397p pd=1.22u as=0.1108p ps=1.1u w=0.22u l=0.28u
X1262 a_2720_2115# a_2689_1609# VSS VSS nfet_03v3 ad=0.1397p pd=1.22u as=0.1108p ps=1.1u w=0.22u l=0.28u
X1263 a_2098_16363# a_2067_15857# VDD VDD pfet_03v3 ad=0.1936p pd=1.76u as=0.1496p ps=1.12u w=0.44u l=0.28u
X1264 a_4586_34995# a_4555_34489# VSS VSS nfet_03v3 ad=0.1397p pd=1.22u as=0.1108p ps=1.1u w=0.22u l=0.28u
X1265 a_3311_15857# WL[14] WBLB[2] VSS nfet_03v3 ad=0.139p pd=1.215u as=0.2362p ps=2.03u w=0.32u l=0.28u
X1266 a_3311_16953# WL[15] WBLB[2] VSS nfet_03v3 ad=0.139p pd=1.215u as=0.2362p ps=2.03u w=0.32u l=0.28u
X1267 RBL[200] a_2067_27913# VSS VSS nfet_03v3 ad=0.1516p pd=1.64u as=0.1516p ps=1.64u w=0.22u l=0.28u
X1268 RBL[192] a_2067_26817# VSS VSS nfet_03v3 ad=0.1516p pd=1.64u as=0.1516p ps=1.64u w=0.22u l=0.28u
X1269 a_2720_28419# a_2689_27913# VSS VSS nfet_03v3 ad=0.1397p pd=1.22u as=0.1108p ps=1.1u w=0.22u l=0.28u
X1270 a_2720_27323# a_2689_26817# VSS VSS nfet_03v3 ad=0.1397p pd=1.22u as=0.1108p ps=1.1u w=0.22u l=0.28u
X1271 a_6452_4307# a_6421_3801# VSS VSS nfet_03v3 ad=0.1397p pd=1.22u as=0.1108p ps=1.1u w=0.22u l=0.28u
X1272 a_2098_7595# WL[6] WBL[0] VSS nfet_03v3 ad=0.1397p pd=1.22u as=0.1706p ps=1.7u w=0.32u l=0.28u
X1273 RBL[204] a_4555_27913# VSS VSS nfet_03v3 ad=0.1516p pd=1.64u as=0.1516p ps=1.64u w=0.22u l=0.28u
X1274 RBL[196] a_4555_26817# VSS VSS nfet_03v3 ad=0.1516p pd=1.64u as=0.1516p ps=1.64u w=0.22u l=0.28u
X1275 a_5830_9787# a_5799_9281# VSS VSS nfet_03v3 ad=0.1397p pd=1.22u as=0.1108p ps=1.1u w=0.22u l=0.28u
X1276 a_6421_12569# WL[11] WBLB[7] VSS nfet_03v3 ad=0.139p pd=1.215u as=0.2362p ps=2.03u w=0.32u l=0.28u
X1277 RBL[173] a_5177_23529# VSS VSS nfet_03v3 ad=0.1516p pd=1.64u as=0.1516p ps=1.64u w=0.22u l=0.28u
X1278 a_2098_22939# WL[20] WBL[0] VSS nfet_03v3 ad=0.1397p pd=1.22u as=0.1706p ps=1.7u w=0.32u l=0.28u
X1279 a_5208_34995# a_5177_34489# VSS VSS nfet_03v3 ad=0.1397p pd=1.22u as=0.1108p ps=1.1u w=0.22u l=0.28u
X1280 a_6452_20747# a_6421_20241# VSS VSS nfet_03v3 ad=0.1397p pd=1.22u as=0.1108p ps=1.1u w=0.22u l=0.28u
X1281 VSS a_2098_3211# a_2067_2705# VSS nfet_03v3 ad=0.1108p pd=1.1u as=0.139p ps=1.215u w=0.22u l=0.28u
X1282 VSS a_2098_2115# a_2067_1609# VSS nfet_03v3 ad=0.1108p pd=1.1u as=0.139p ps=1.215u w=0.22u l=0.28u
X1283 a_3964_33899# WL[30] WBL[3] VSS nfet_03v3 ad=0.1397p pd=1.22u as=0.1706p ps=1.7u w=0.32u l=0.28u
X1284 a_3964_32803# WL[29] WBL[3] VSS nfet_03v3 ad=0.1397p pd=1.22u as=0.1706p ps=1.7u w=0.32u l=0.28u
X1285 VDD a_6452_29515# a_6421_29009# VDD pfet_03v3 ad=0.1496p pd=1.12u as=0.1936p ps=1.76u w=0.44u l=0.28u
X1286 VDD a_6452_28419# a_6421_27913# VDD pfet_03v3 ad=0.1496p pd=1.12u as=0.1936p ps=1.76u w=0.44u l=0.28u
X1287 RBL[211] a_3933_29009# A[26] VDD pfet_03v3 ad=0.2082p pd=1.84u as=0.2024p ps=1.8u w=0.44u l=0.28u
X1288 RBL[132] a_4555_18049# A[16] VDD pfet_03v3 ad=0.2082p pd=1.84u as=0.2024p ps=1.8u w=0.44u l=0.28u
X1289 RBL[140] a_4555_19145# A[17] VDD pfet_03v3 ad=0.2082p pd=1.84u as=0.2024p ps=1.8u w=0.44u l=0.28u
X1290 RBL[255] a_6452_34995# A[31] VSS nfet_03v3 ad=0.1516p pd=1.64u as=0.1516p ps=1.64u w=0.22u l=0.28u
X1291 a_4586_34995# WL[31] WBL[4] VSS nfet_03v3 ad=0.1397p pd=1.22u as=0.1706p ps=1.7u w=0.32u l=0.28u
X1292 RBL[96] a_2098_14171# A[12] VSS nfet_03v3 ad=0.1516p pd=1.64u as=0.1516p ps=1.64u w=0.22u l=0.28u
X1293 RBL[104] a_2098_15267# A[13] VSS nfet_03v3 ad=0.1516p pd=1.64u as=0.1516p ps=1.64u w=0.22u l=0.28u
X1294 RBL[219] a_3933_30105# VSS VSS nfet_03v3 ad=0.1516p pd=1.64u as=0.1516p ps=1.64u w=0.22u l=0.28u
X1295 a_2689_27913# WL[25] WBLB[1] VSS nfet_03v3 ad=0.139p pd=1.215u as=0.2362p ps=2.03u w=0.32u l=0.28u
X1296 a_2689_26817# WL[24] WBLB[1] VSS nfet_03v3 ad=0.139p pd=1.215u as=0.2362p ps=2.03u w=0.32u l=0.28u
X1297 a_3311_23529# WL[21] WBLB[2] VSS nfet_03v3 ad=0.139p pd=1.215u as=0.2362p ps=2.03u w=0.32u l=0.28u
X1298 RBL[248] a_2067_34489# a_2311_35171# VSS nfet_03v3 ad=0.1516p pd=1.64u as=0.1516p ps=1.64u w=0.22u l=0.28u
X1299 VSS a_4586_5403# a_4555_4897# VSS nfet_03v3 ad=0.1108p pd=1.1u as=0.139p ps=1.215u w=0.22u l=0.28u
X1300 RBL[133] a_5177_18049# A[16] VDD pfet_03v3 ad=0.2082p pd=1.84u as=0.2024p ps=1.8u w=0.44u l=0.28u
X1301 RBL[141] a_5177_19145# A[17] VDD pfet_03v3 ad=0.2082p pd=1.84u as=0.2024p ps=1.8u w=0.44u l=0.28u
X1302 VSS a_2720_33899# a_2689_33393# VSS nfet_03v3 ad=0.1108p pd=1.1u as=0.139p ps=1.215u w=0.22u l=0.28u
X1303 VSS a_2720_32803# a_2689_32297# VSS nfet_03v3 ad=0.1108p pd=1.1u as=0.139p ps=1.215u w=0.22u l=0.28u
X1304 VSS a_3342_30611# a_3311_30105# VSS nfet_03v3 ad=0.1108p pd=1.1u as=0.139p ps=1.215u w=0.22u l=0.28u
X1305 RBL[145] a_2689_20241# VSS VSS nfet_03v3 ad=0.1516p pd=1.64u as=0.1516p ps=1.64u w=0.22u l=0.28u
X1306 a_5177_34489# WL[31] WBLB[5] VSS nfet_03v3 ad=0.139p pd=1.215u as=0.2362p ps=2.03u w=0.32u l=0.28u
X1307 RBL[252] a_4555_34489# a_4799_35171# VSS nfet_03v3 ad=0.1516p pd=1.64u as=0.1516p ps=1.64u w=0.22u l=0.28u
X1308 VSS a_5208_28419# a_5177_27913# VSS nfet_03v3 ad=0.1108p pd=1.1u as=0.139p ps=1.215u w=0.22u l=0.28u
X1309 VSS a_5208_27323# a_5177_26817# VSS nfet_03v3 ad=0.1108p pd=1.1u as=0.139p ps=1.215u w=0.22u l=0.28u
X1310 a_4586_21843# a_4555_21337# VDD VDD pfet_03v3 ad=0.1936p pd=1.76u as=0.1496p ps=1.12u w=0.44u l=0.28u
X1311 VSS a_5830_30611# a_5799_30105# VSS nfet_03v3 ad=0.1108p pd=1.1u as=0.139p ps=1.215u w=0.22u l=0.28u
X1312 a_4586_4307# a_4555_3801# VSS VSS nfet_03v3 ad=0.1397p pd=1.22u as=0.1108p ps=1.1u w=0.22u l=0.28u
X1313 RBL[40] a_2067_5993# A[5] VDD pfet_03v3 ad=0.2082p pd=1.84u as=0.2024p ps=1.8u w=0.44u l=0.28u
X1314 a_4555_19145# WL[17] WBLB[4] VSS nfet_03v3 ad=0.139p pd=1.215u as=0.2362p ps=2.03u w=0.32u l=0.28u
X1315 a_2720_21843# WL[19] WBL[1] VSS nfet_03v3 ad=0.1397p pd=1.22u as=0.1706p ps=1.7u w=0.32u l=0.28u
X1316 a_2720_14171# a_2689_13665# VDD VDD pfet_03v3 ad=0.1936p pd=1.76u as=0.1496p ps=1.12u w=0.44u l=0.28u
X1317 VDD a_3964_26227# a_3933_25721# VDD pfet_03v3 ad=0.1496p pd=1.12u as=0.1936p ps=1.76u w=0.44u l=0.28u
X1318 a_2098_25131# a_2067_24625# VDD VDD pfet_03v3 ad=0.1936p pd=1.76u as=0.1496p ps=1.12u w=0.44u l=0.28u
X1319 VSS a_3964_16363# a_3933_15857# VSS nfet_03v3 ad=0.1108p pd=1.1u as=0.139p ps=1.215u w=0.22u l=0.28u
X1320 VSS a_3964_17459# a_3933_16953# VSS nfet_03v3 ad=0.1108p pd=1.1u as=0.139p ps=1.215u w=0.22u l=0.28u
X1321 RBL[57] a_2720_8691# A[7] VSS nfet_03v3 ad=0.1516p pd=1.64u as=0.1516p ps=1.64u w=0.22u l=0.28u
X1322 RBL[65] a_2720_9787# A[8] VSS nfet_03v3 ad=0.1516p pd=1.64u as=0.1516p ps=1.64u w=0.22u l=0.28u
X1323 RBL[204] a_4586_28419# A[25] VSS nfet_03v3 ad=0.1516p pd=1.64u as=0.1516p ps=1.64u w=0.22u l=0.28u
X1324 RBL[196] a_4586_27323# A[24] VSS nfet_03v3 ad=0.1516p pd=1.64u as=0.1516p ps=1.64u w=0.22u l=0.28u
X1325 RBL[173] a_5208_24035# A[21] VSS nfet_03v3 ad=0.1516p pd=1.64u as=0.1516p ps=1.64u w=0.22u l=0.28u
X1326 a_5208_21843# a_5177_21337# VDD VDD pfet_03v3 ad=0.1936p pd=1.76u as=0.1496p ps=1.12u w=0.44u l=0.28u
X1327 RBL[114] a_3342_16363# A[14] VSS nfet_03v3 ad=0.1516p pd=1.64u as=0.1516p ps=1.64u w=0.22u l=0.28u
X1328 RBL[122] a_3342_17459# A[15] VSS nfet_03v3 ad=0.1516p pd=1.64u as=0.1516p ps=1.64u w=0.22u l=0.28u
X1329 a_3933_29009# WL[26] WBLB[3] VSS nfet_03v3 ad=0.139p pd=1.215u as=0.2362p ps=2.03u w=0.32u l=0.28u
X1330 a_3964_10883# WL[9] WBL[3] VSS nfet_03v3 ad=0.1397p pd=1.22u as=0.1706p ps=1.7u w=0.32u l=0.28u
X1331 a_3964_11979# WL[10] WBL[3] VSS nfet_03v3 ad=0.1397p pd=1.22u as=0.1706p ps=1.7u w=0.32u l=0.28u
X1332 a_5208_4307# a_5177_3801# VDD VDD pfet_03v3 ad=0.1936p pd=1.76u as=0.1496p ps=1.12u w=0.44u l=0.28u
X1333 RBL[95] a_6452_13075# A[11] VSS nfet_03v3 ad=0.1516p pd=1.64u as=0.1516p ps=1.64u w=0.22u l=0.28u
X1334 RBL[170] a_3311_23529# VSS VSS nfet_03v3 ad=0.1516p pd=1.64u as=0.1516p ps=1.64u w=0.22u l=0.28u
X1335 RBL[86] a_5799_11473# A[10] VDD pfet_03v3 ad=0.2082p pd=1.84u as=0.2024p ps=1.8u w=0.44u l=0.28u
X1336 a_4586_13075# WL[11] WBL[4] VSS nfet_03v3 ad=0.1397p pd=1.22u as=0.1706p ps=1.7u w=0.32u l=0.28u
X1337 a_3342_34995# a_3311_34489# VSS VSS nfet_03v3 ad=0.1397p pd=1.22u as=0.1108p ps=1.1u w=0.22u l=0.28u
X1338 a_3964_31707# a_3933_31201# VSS VSS nfet_03v3 ad=0.1397p pd=1.22u as=0.1108p ps=1.1u w=0.22u l=0.28u
X1339 a_2067_15857# WL[14] WBLB[0] VSS nfet_03v3 ad=0.139p pd=1.215u as=0.2362p ps=2.03u w=0.32u l=0.28u
X1340 a_2067_16953# WL[15] WBLB[0] VSS nfet_03v3 ad=0.139p pd=1.215u as=0.2362p ps=2.03u w=0.32u l=0.28u
X1341 a_4586_20747# a_4555_20241# VSS VSS nfet_03v3 ad=0.1397p pd=1.22u as=0.1108p ps=1.1u w=0.22u l=0.28u
X1342 RBL[88] a_2067_12569# VSS VSS nfet_03v3 ad=0.1516p pd=1.64u as=0.1516p ps=1.64u w=0.22u l=0.28u
X1343 RBL[214] a_5830_29515# A[26] VSS nfet_03v3 ad=0.1516p pd=1.64u as=0.1516p ps=1.64u w=0.22u l=0.28u
X1344 a_2720_13075# a_2689_12569# VSS VSS nfet_03v3 ad=0.1397p pd=1.22u as=0.1108p ps=1.1u w=0.22u l=0.28u
X1345 a_2720_14171# a_2689_13665# VSS VSS nfet_03v3 ad=0.1397p pd=1.22u as=0.1108p ps=1.1u w=0.22u l=0.28u
X1346 VDD a_2720_20747# a_2689_20241# VDD pfet_03v3 ad=0.1496p pd=1.12u as=0.1936p ps=1.76u w=0.44u l=0.28u
X1347 a_2098_32803# a_2067_32297# VDD VDD pfet_03v3 ad=0.1936p pd=1.76u as=0.1496p ps=1.12u w=0.44u l=0.28u
X1348 a_2098_25131# a_2067_24625# VSS VSS nfet_03v3 ad=0.1397p pd=1.22u as=0.1108p ps=1.1u w=0.22u l=0.28u
X1349 a_2098_24035# a_2067_23529# VSS VSS nfet_03v3 ad=0.1397p pd=1.22u as=0.1108p ps=1.1u w=0.22u l=0.28u
X1350 a_3311_513# WL[0] WBLB[2] VSS nfet_03v3 ad=0.139p pd=1.215u as=0.2362p ps=2.03u w=0.32u l=0.28u
X1351 VDD a_4586_29515# a_4555_29009# VDD pfet_03v3 ad=0.1496p pd=1.12u as=0.1936p ps=1.76u w=0.44u l=0.28u
X1352 VDD a_4586_28419# a_4555_27913# VDD pfet_03v3 ad=0.1496p pd=1.12u as=0.1936p ps=1.76u w=0.44u l=0.28u
X1353 a_3933_3801# WL[3] WBLB[3] VSS nfet_03v3 ad=0.139p pd=1.215u as=0.2362p ps=2.03u w=0.32u l=0.28u
X1354 a_3933_2705# WL[2] WBLB[3] VSS nfet_03v3 ad=0.139p pd=1.215u as=0.2362p ps=2.03u w=0.32u l=0.28u
X1355 a_5177_12569# WL[11] WBLB[5] VSS nfet_03v3 ad=0.139p pd=1.215u as=0.2362p ps=2.03u w=0.32u l=0.28u
X1356 RBL[7] a_6421_513# A[0] VDD pfet_03v3 ad=0.2082p pd=1.84u as=0.2024p ps=1.8u w=0.44u l=0.28u
X1357 RBL[92] a_4555_12569# VSS VSS nfet_03v3 ad=0.1516p pd=1.64u as=0.1516p ps=1.64u w=0.22u l=0.28u
X1358 RBL[252] a_4586_34995# A[31] VSS nfet_03v3 ad=0.1516p pd=1.64u as=0.1516p ps=1.64u w=0.22u l=0.28u
X1359 RBL[95] a_6421_12569# A[11] VDD pfet_03v3 ad=0.2082p pd=1.84u as=0.2024p ps=1.8u w=0.44u l=0.28u
X1360 VDD a_5208_14171# a_5177_13665# VDD pfet_03v3 ad=0.1496p pd=1.12u as=0.1936p ps=1.76u w=0.44u l=0.28u
X1361 RBL[5] a_5177_513# VSS VSS nfet_03v3 ad=0.1516p pd=1.64u as=0.1516p ps=1.64u w=0.22u l=0.28u
X1362 RBL[59] a_3933_8185# A[7] VDD pfet_03v3 ad=0.2082p pd=1.84u as=0.2024p ps=1.8u w=0.44u l=0.28u
X1363 a_5208_20747# a_5177_20241# VSS VSS nfet_03v3 ad=0.1397p pd=1.22u as=0.1108p ps=1.1u w=0.22u l=0.28u
X1364 RBL[51] a_3933_7089# A[6] VDD pfet_03v3 ad=0.2082p pd=1.84u as=0.2024p ps=1.8u w=0.44u l=0.28u
X1365 a_5799_13665# WL[12] WBLB[6] VSS nfet_03v3 ad=0.139p pd=1.215u as=0.2362p ps=2.03u w=0.32u l=0.28u
X1366 a_5799_14761# WL[13] WBLB[6] VSS nfet_03v3 ad=0.139p pd=1.215u as=0.2362p ps=2.03u w=0.32u l=0.28u
X1367 RBL[130] a_3311_18049# A[16] VDD pfet_03v3 ad=0.2082p pd=1.84u as=0.2024p ps=1.8u w=0.44u l=0.28u
X1368 RBL[138] a_3311_19145# A[17] VDD pfet_03v3 ad=0.2082p pd=1.84u as=0.2024p ps=1.8u w=0.44u l=0.28u
X1369 RBL[107] a_3933_14761# A[13] VDD pfet_03v3 ad=0.2082p pd=1.84u as=0.2024p ps=1.8u w=0.44u l=0.28u
X1370 RBL[115] a_3933_15857# A[14] VDD pfet_03v3 ad=0.2082p pd=1.84u as=0.2024p ps=1.8u w=0.44u l=0.28u
X1371 a_3342_4307# a_3311_3801# VDD VDD pfet_03v3 ad=0.1936p pd=1.76u as=0.1496p ps=1.12u w=0.44u l=0.28u
X1372 a_3933_513# WL[0] WBLB[3] VSS nfet_03v3 ad=0.139p pd=1.215u as=0.2362p ps=2.03u w=0.32u l=0.28u
X1373 RBL[65] a_2689_9281# A[8] VDD pfet_03v3 ad=0.2082p pd=1.84u as=0.2024p ps=1.8u w=0.44u l=0.28u
X1374 RBL[198] a_5799_26817# A[24] VDD pfet_03v3 ad=0.2082p pd=1.84u as=0.2024p ps=1.8u w=0.44u l=0.28u
X1375 RBL[190] a_5799_25721# A[23] VDD pfet_03v3 ad=0.2082p pd=1.84u as=0.2024p ps=1.8u w=0.44u l=0.28u
X1376 VSS a_6452_6499# a_6421_5993# VSS nfet_03v3 ad=0.1108p pd=1.1u as=0.139p ps=1.215u w=0.22u l=0.28u
X1377 a_3342_34995# WL[31] WBL[2] VSS nfet_03v3 ad=0.1397p pd=1.22u as=0.1706p ps=1.7u w=0.32u l=0.28u
X1378 a_2098_9787# a_2067_9281# VSS VSS nfet_03v3 ad=0.1397p pd=1.22u as=0.1108p ps=1.1u w=0.22u l=0.28u
X1379 a_3311_1609# WL[1] WBLB[2] VSS nfet_03v3 ad=0.139p pd=1.215u as=0.2362p ps=2.03u w=0.32u l=0.28u
X1380 a_2689_19145# WL[17] WBLB[1] VSS nfet_03v3 ad=0.139p pd=1.215u as=0.2362p ps=2.03u w=0.32u l=0.28u
X1381 a_2067_23529# WL[21] WBLB[0] VSS nfet_03v3 ad=0.139p pd=1.215u as=0.2362p ps=2.03u w=0.32u l=0.28u
X1382 a_5208_4307# a_5177_3801# VSS VSS nfet_03v3 ad=0.1397p pd=1.22u as=0.1108p ps=1.1u w=0.22u l=0.28u
X1383 VSS a_2098_16363# a_2067_15857# VSS nfet_03v3 ad=0.1108p pd=1.1u as=0.139p ps=1.215u w=0.22u l=0.28u
X1384 VSS a_2098_17459# a_2067_16953# VSS nfet_03v3 ad=0.1108p pd=1.1u as=0.139p ps=1.215u w=0.22u l=0.28u
X1385 VDD a_2098_26227# a_2067_25721# VDD pfet_03v3 ad=0.1496p pd=1.12u as=0.1936p ps=1.76u w=0.44u l=0.28u
X1386 a_5830_29515# WL[26] WBL[6] VSS nfet_03v3 ad=0.1397p pd=1.22u as=0.1706p ps=1.7u w=0.32u l=0.28u
X1387 VDD a_5830_8691# a_5799_8185# VDD pfet_03v3 ad=0.1496p pd=1.12u as=0.1936p ps=1.76u w=0.44u l=0.28u
X1388 VDD a_5830_9787# a_5799_9281# VDD pfet_03v3 ad=0.1496p pd=1.12u as=0.1936p ps=1.76u w=0.44u l=0.28u
X1389 RBL[224] a_2098_31707# A[28] VSS nfet_03v3 ad=0.1516p pd=1.64u as=0.1516p ps=1.64u w=0.22u l=0.28u
X1390 a_6452_31707# WL[28] WBL[7] VSS nfet_03v3 ad=0.1397p pd=1.22u as=0.1706p ps=1.7u w=0.32u l=0.28u
X1391 VSS a_5208_14171# a_5177_13665# VSS nfet_03v3 ad=0.1108p pd=1.1u as=0.139p ps=1.215u w=0.22u l=0.28u
X1392 a_3342_21843# a_3311_21337# VDD VDD pfet_03v3 ad=0.1936p pd=1.76u as=0.1496p ps=1.12u w=0.44u l=0.28u
X1393 a_6452_4307# WL[3] WBL[7] VSS nfet_03v3 ad=0.1397p pd=1.22u as=0.1706p ps=1.7u w=0.32u l=0.28u
X1394 a_6452_3211# WL[2] WBL[7] VSS nfet_03v3 ad=0.1397p pd=1.22u as=0.1706p ps=1.7u w=0.32u l=0.28u
X1395 VSS a_5208_13075# a_5177_12569# VSS nfet_03v3 ad=0.1108p pd=1.1u as=0.139p ps=1.215u w=0.22u l=0.28u
X1396 RBL[207] a_6421_27913# A[25] VDD pfet_03v3 ad=0.2082p pd=1.84u as=0.2024p ps=1.8u w=0.44u l=0.28u
X1397 RBL[49] a_2689_7089# VSS VSS nfet_03v3 ad=0.1516p pd=1.64u as=0.1516p ps=1.64u w=0.22u l=0.28u
X1398 a_2098_10883# a_2067_10377# VDD VDD pfet_03v3 ad=0.1936p pd=1.76u as=0.1496p ps=1.12u w=0.44u l=0.28u
X1399 RBL[2] a_3311_513# VSS VSS nfet_03v3 ad=0.1516p pd=1.64u as=0.1516p ps=1.64u w=0.22u l=0.28u
X1400 VDD a_3964_17459# a_3933_16953# VDD pfet_03v3 ad=0.1496p pd=1.12u as=0.1936p ps=1.76u w=0.44u l=0.28u
X1401 VDD a_3964_18555# a_3933_18049# VDD pfet_03v3 ad=0.1496p pd=1.12u as=0.1936p ps=1.76u w=0.44u l=0.28u
X1402 a_5799_5993# WL[5] WBLB[6] VSS nfet_03v3 ad=0.139p pd=1.215u as=0.2362p ps=2.03u w=0.32u l=0.28u
X1403 a_5799_4897# WL[4] WBLB[6] VSS nfet_03v3 ad=0.139p pd=1.215u as=0.2362p ps=2.03u w=0.32u l=0.28u
X1404 RBL[92] a_4586_13075# A[11] VSS nfet_03v3 ad=0.1516p pd=1.64u as=0.1516p ps=1.64u w=0.22u l=0.28u
X1405 a_5799_22433# WL[20] WBLB[6] VSS nfet_03v3 ad=0.139p pd=1.215u as=0.2362p ps=2.03u w=0.32u l=0.28u
X1406 VDD a_5208_6499# a_5177_5993# VDD pfet_03v3 ad=0.1496p pd=1.12u as=0.1936p ps=1.76u w=0.44u l=0.28u
X1407 VDD a_5208_7595# a_5177_7089# VDD pfet_03v3 ad=0.1496p pd=1.12u as=0.1936p ps=1.76u w=0.44u l=0.28u
X1408 RBL[2] a_3311_513# A[0] VDD pfet_03v3 ad=0.2082p pd=1.84u as=0.2024p ps=1.8u w=0.44u l=0.28u
X1409 RBL[234] a_3342_32803# A[29] VSS nfet_03v3 ad=0.1516p pd=1.64u as=0.1516p ps=1.64u w=0.22u l=0.28u
X1410 RBL[211] a_3964_29515# A[26] VSS nfet_03v3 ad=0.1516p pd=1.64u as=0.1516p ps=1.64u w=0.22u l=0.28u
X1411 RBL[2] a_3342_1019# A[0] VSS nfet_03v3 ad=0.1516p pd=1.64u as=0.1516p ps=1.64u w=0.22u l=0.28u
X1412 a_5830_2115# WL[1] WBL[6] VSS nfet_03v3 ad=0.1397p pd=1.22u as=0.1706p ps=1.7u w=0.32u l=0.28u
X1413 a_5208_20747# WL[18] WBL[5] VSS nfet_03v3 ad=0.1397p pd=1.22u as=0.1706p ps=1.7u w=0.32u l=0.28u
X1414 VSS a_4586_6499# a_4555_5993# VSS nfet_03v3 ad=0.1108p pd=1.1u as=0.139p ps=1.215u w=0.22u l=0.28u
X1415 VSS a_5830_8691# a_5799_8185# VSS nfet_03v3 ad=0.1108p pd=1.1u as=0.139p ps=1.215u w=0.22u l=0.28u
X1416 VSS a_6452_15267# a_6421_14761# VSS nfet_03v3 ad=0.1108p pd=1.1u as=0.139p ps=1.215u w=0.22u l=0.28u
X1417 RBL[171] a_3933_23529# A[21] VDD pfet_03v3 ad=0.2082p pd=1.84u as=0.2024p ps=1.8u w=0.44u l=0.28u
X1418 RBL[92] a_4555_12569# A[11] VDD pfet_03v3 ad=0.2082p pd=1.84u as=0.2024p ps=1.8u w=0.44u l=0.28u
X1419 RBL[129] a_2720_18555# A[16] VSS nfet_03v3 ad=0.1516p pd=1.64u as=0.1516p ps=1.64u w=0.22u l=0.28u
X1420 a_3342_4307# a_3311_3801# VSS VSS nfet_03v3 ad=0.1397p pd=1.22u as=0.1108p ps=1.1u w=0.22u l=0.28u
X1421 a_3342_13075# WL[11] WBL[2] VSS nfet_03v3 ad=0.1397p pd=1.22u as=0.1706p ps=1.7u w=0.32u l=0.28u
X1422 a_3342_20747# a_3311_20241# VSS VSS nfet_03v3 ad=0.1397p pd=1.22u as=0.1108p ps=1.1u w=0.22u l=0.28u
X1423 RBL[254] a_5799_34489# A[31] VDD pfet_03v3 ad=0.2082p pd=1.84u as=0.2024p ps=1.8u w=0.44u l=0.28u
X1424 RBL[102] a_5830_14171# A[12] VSS nfet_03v3 ad=0.1516p pd=1.64u as=0.1516p ps=1.64u w=0.22u l=0.28u
X1425 RBL[110] a_5830_15267# A[13] VSS nfet_03v3 ad=0.1516p pd=1.64u as=0.1516p ps=1.64u w=0.22u l=0.28u
X1426 a_2720_15267# a_2689_14761# VDD VDD pfet_03v3 ad=0.1936p pd=1.76u as=0.1496p ps=1.12u w=0.44u l=0.28u
X1427 RBL[93] a_5177_12569# A[11] VDD pfet_03v3 ad=0.2082p pd=1.84u as=0.2024p ps=1.8u w=0.44u l=0.28u
X1428 RBL[22] a_5830_3211# A[2] VSS nfet_03v3 ad=0.1516p pd=1.64u as=0.1516p ps=1.64u w=0.22u l=0.28u
X1429 a_6421_21337# WL[19] WBLB[7] VSS nfet_03v3 ad=0.139p pd=1.215u as=0.2362p ps=2.03u w=0.32u l=0.28u
X1430 a_2098_31707# WL[28] WBL[0] VSS nfet_03v3 ad=0.1397p pd=1.22u as=0.1706p ps=1.7u w=0.32u l=0.28u
X1431 RBL[31] a_6421_3801# VSS VSS nfet_03v3 ad=0.1516p pd=1.64u as=0.1516p ps=1.64u w=0.22u l=0.28u
X1432 a_6452_30611# a_6421_30105# VSS VSS nfet_03v3 ad=0.1397p pd=1.22u as=0.1108p ps=1.1u w=0.22u l=0.28u
X1433 a_4555_13665# WL[12] WBLB[4] VSS nfet_03v3 ad=0.139p pd=1.215u as=0.2362p ps=2.03u w=0.32u l=0.28u
X1434 a_4555_14761# WL[13] WBLB[4] VSS nfet_03v3 ad=0.139p pd=1.215u as=0.2362p ps=2.03u w=0.32u l=0.28u
X1435 VSS a_6452_29515# a_6421_29009# VSS nfet_03v3 ad=0.1108p pd=1.1u as=0.139p ps=1.215u w=0.22u l=0.28u
X1436 RBL[142] a_5799_19145# VSS VSS nfet_03v3 ad=0.1516p pd=1.64u as=0.1516p ps=1.64u w=0.22u l=0.28u
X1437 RBL[204] a_4555_27913# A[25] VDD pfet_03v3 ad=0.2082p pd=1.84u as=0.2024p ps=1.8u w=0.44u l=0.28u
X1438 a_5208_1019# WL[0] WBL[5] VSS nfet_03v3 ad=0.1397p pd=1.22u as=0.1706p ps=1.7u w=0.32u l=0.28u
X1439 VDD a_2098_18555# a_2067_18049# VDD pfet_03v3 ad=0.1496p pd=1.12u as=0.1936p ps=1.76u w=0.44u l=0.28u
X1440 RBL[31] a_6452_4307# A[3] VSS nfet_03v3 ad=0.1516p pd=1.64u as=0.1516p ps=1.64u w=0.22u l=0.28u
X1441 RBL[13] a_5208_2115# A[1] VSS nfet_03v3 ad=0.1516p pd=1.64u as=0.1516p ps=1.64u w=0.22u l=0.28u
X1442 VDD a_2098_17459# a_2067_16953# VDD pfet_03v3 ad=0.1496p pd=1.12u as=0.1936p ps=1.76u w=0.44u l=0.28u
X1443 RBL[168] a_2098_24035# A[21] VSS nfet_03v3 ad=0.1516p pd=1.64u as=0.1516p ps=1.64u w=0.22u l=0.28u
X1444 a_3311_33393# WL[30] WBLB[2] VSS nfet_03v3 ad=0.139p pd=1.215u as=0.2362p ps=2.03u w=0.32u l=0.28u
X1445 a_3311_32297# WL[29] WBLB[2] VSS nfet_03v3 ad=0.139p pd=1.215u as=0.2362p ps=2.03u w=0.32u l=0.28u
X1446 VDD a_3342_6499# a_3311_5993# VDD pfet_03v3 ad=0.1496p pd=1.12u as=0.1936p ps=1.76u w=0.44u l=0.28u
X1447 VDD a_3342_7595# a_3311_7089# VDD pfet_03v3 ad=0.1496p pd=1.12u as=0.1936p ps=1.76u w=0.44u l=0.28u
X1448 RBL[205] a_5177_27913# A[25] VDD pfet_03v3 ad=0.2082p pd=1.84u as=0.2024p ps=1.8u w=0.44u l=0.28u
X1449 RBL[103] a_6421_13665# A[12] VDD pfet_03v3 ad=0.2082p pd=1.84u as=0.2024p ps=1.8u w=0.44u l=0.28u
X1450 VDD a_5208_15267# a_5177_14761# VDD pfet_03v3 ad=0.1496p pd=1.12u as=0.1936p ps=1.76u w=0.44u l=0.28u
X1451 a_5208_30611# WL[27] WBL[5] VSS nfet_03v3 ad=0.1397p pd=1.22u as=0.1706p ps=1.7u w=0.32u l=0.28u
X1452 RBL[19] a_3964_3211# A[2] VSS nfet_03v3 ad=0.1516p pd=1.64u as=0.1516p ps=1.64u w=0.22u l=0.28u
X1453 a_4555_22433# WL[20] WBLB[4] VSS nfet_03v3 ad=0.139p pd=1.215u as=0.2362p ps=2.03u w=0.32u l=0.28u
X1454 a_2720_24035# a_2689_23529# VDD VDD pfet_03v3 ad=0.1936p pd=1.76u as=0.1496p ps=1.12u w=0.44u l=0.28u
X1455 VSS a_3964_26227# a_3933_25721# VSS nfet_03v3 ad=0.1108p pd=1.1u as=0.139p ps=1.215u w=0.22u l=0.28u
X1456 VSS a_4586_15267# a_4555_14761# VSS nfet_03v3 ad=0.1108p pd=1.1u as=0.139p ps=1.215u w=0.22u l=0.28u
X1457 a_2720_22939# a_2689_22433# VDD VDD pfet_03v3 ad=0.1936p pd=1.76u as=0.1496p ps=1.12u w=0.44u l=0.28u
X1458 VDD a_3964_34995# a_3933_34489# VDD pfet_03v3 ad=0.1496p pd=1.12u as=0.1936p ps=1.76u w=0.44u l=0.28u
X1459 VDD a_3964_33899# a_3933_33393# VDD pfet_03v3 ad=0.1496p pd=1.12u as=0.1936p ps=1.76u w=0.44u l=0.28u
X1460 a_5830_5403# a_5799_4897# VDD VDD pfet_03v3 ad=0.1936p pd=1.76u as=0.1496p ps=1.12u w=0.44u l=0.28u
X1461 a_2067_1609# WL[1] WBLB[0] VSS nfet_03v3 ad=0.139p pd=1.215u as=0.2362p ps=2.03u w=0.32u l=0.28u
X1462 VDD a_3342_19651# a_3311_19145# VDD pfet_03v3 ad=0.1496p pd=1.12u as=0.1936p ps=1.76u w=0.44u l=0.28u
X1463 RBL[186] a_3342_26227# A[23] VSS nfet_03v3 ad=0.1516p pd=1.64u as=0.1516p ps=1.64u w=0.22u l=0.28u
X1464 RBL[99] a_3964_14171# A[12] VSS nfet_03v3 ad=0.1516p pd=1.64u as=0.1516p ps=1.64u w=0.22u l=0.28u
X1465 RBL[107] a_3964_15267# A[13] VSS nfet_03v3 ad=0.1516p pd=1.64u as=0.1516p ps=1.64u w=0.22u l=0.28u
X1466 RBL[178] a_3342_25131# A[22] VSS nfet_03v3 ad=0.1516p pd=1.64u as=0.1516p ps=1.64u w=0.22u l=0.28u
X1467 a_3964_20747# WL[18] WBL[3] VSS nfet_03v3 ad=0.1397p pd=1.22u as=0.1706p ps=1.7u w=0.32u l=0.28u
X1468 VDD a_5830_19651# a_5799_19145# VDD pfet_03v3 ad=0.1496p pd=1.12u as=0.1936p ps=1.76u w=0.44u l=0.28u
X1469 RBL[90] a_3311_12569# A[11] VDD pfet_03v3 ad=0.2082p pd=1.84u as=0.2024p ps=1.8u w=0.44u l=0.28u
X1470 VDD a_6452_16363# a_6421_15857# VDD pfet_03v3 ad=0.1496p pd=1.12u as=0.1936p ps=1.76u w=0.44u l=0.28u
X1471 RBL[75] a_3933_10377# A[9] VDD pfet_03v3 ad=0.2082p pd=1.84u as=0.2024p ps=1.8u w=0.44u l=0.28u
X1472 RBL[159] a_6452_21843# A[19] VSS nfet_03v3 ad=0.1516p pd=1.64u as=0.1516p ps=1.64u w=0.22u l=0.28u
X1473 RBL[167] a_6452_22939# A[20] VSS nfet_03v3 ad=0.1516p pd=1.64u as=0.1516p ps=1.64u w=0.22u l=0.28u
X1474 RBL[28] a_4586_4307# A[3] VSS nfet_03v3 ad=0.1516p pd=1.64u as=0.1516p ps=1.64u w=0.22u l=0.28u
X1475 RBL[150] a_5799_20241# A[18] VDD pfet_03v3 ad=0.2082p pd=1.84u as=0.2024p ps=1.8u w=0.44u l=0.28u
X1476 RBL[158] a_5799_21337# A[19] VDD pfet_03v3 ad=0.2082p pd=1.84u as=0.2024p ps=1.8u w=0.44u l=0.28u
X1477 a_4555_5993# WL[5] WBLB[4] VSS nfet_03v3 ad=0.139p pd=1.215u as=0.2362p ps=2.03u w=0.32u l=0.28u
X1478 a_4555_4897# WL[4] WBLB[4] VSS nfet_03v3 ad=0.139p pd=1.215u as=0.2362p ps=2.03u w=0.32u l=0.28u
X1479 a_4586_21843# WL[19] WBL[4] VSS nfet_03v3 ad=0.1397p pd=1.22u as=0.1706p ps=1.7u w=0.32u l=0.28u
X1480 a_4586_30611# a_4555_30105# VSS VSS nfet_03v3 ad=0.1397p pd=1.22u as=0.1108p ps=1.1u w=0.22u l=0.28u
X1481 a_2689_13665# WL[12] WBLB[1] VSS nfet_03v3 ad=0.139p pd=1.215u as=0.2362p ps=2.03u w=0.32u l=0.28u
X1482 a_2689_14761# WL[13] WBLB[1] VSS nfet_03v3 ad=0.139p pd=1.215u as=0.2362p ps=2.03u w=0.32u l=0.28u
X1483 a_3311_10377# WL[9] WBLB[2] VSS nfet_03v3 ad=0.139p pd=1.215u as=0.2362p ps=2.03u w=0.32u l=0.28u
X1484 a_3311_11473# WL[10] WBLB[2] VSS nfet_03v3 ad=0.139p pd=1.215u as=0.2362p ps=2.03u w=0.32u l=0.28u
X1485 RBL[14] a_5799_1609# VSS VSS nfet_03v3 ad=0.1516p pd=1.64u as=0.1516p ps=1.64u w=0.22u l=0.28u
X1486 RBL[230] a_5830_31707# A[28] VSS nfet_03v3 ad=0.1516p pd=1.64u as=0.1516p ps=1.64u w=0.22u l=0.28u
X1487 VDD a_5830_3211# a_5799_2705# VDD pfet_03v3 ad=0.1496p pd=1.12u as=0.1936p ps=1.76u w=0.44u l=0.28u
X1488 RBL[152] a_2067_21337# VSS VSS nfet_03v3 ad=0.1516p pd=1.64u as=0.1516p ps=1.64u w=0.22u l=0.28u
X1489 RBL[160] a_2067_22433# VSS VSS nfet_03v3 ad=0.1516p pd=1.64u as=0.1516p ps=1.64u w=0.22u l=0.28u
X1490 a_2098_33899# a_2067_33393# VSS VSS nfet_03v3 ad=0.1397p pd=1.22u as=0.1108p ps=1.1u w=0.22u l=0.28u
X1491 a_2098_32803# a_2067_32297# VSS VSS nfet_03v3 ad=0.1397p pd=1.22u as=0.1108p ps=1.1u w=0.22u l=0.28u
X1492 a_2720_31707# a_2689_31201# VDD VDD pfet_03v3 ad=0.1936p pd=1.76u as=0.1496p ps=1.12u w=0.44u l=0.28u
X1493 a_2720_30611# a_2689_30105# VDD VDD pfet_03v3 ad=0.1936p pd=1.76u as=0.1496p ps=1.12u w=0.44u l=0.28u
X1494 a_2098_2115# WL[1] WBL[0] VSS nfet_03v3 ad=0.1397p pd=1.22u as=0.1706p ps=1.7u w=0.32u l=0.28u
X1495 a_2720_21843# a_2689_21337# VSS VSS nfet_03v3 ad=0.1397p pd=1.22u as=0.1108p ps=1.1u w=0.22u l=0.28u
X1496 a_2720_22939# a_2689_22433# VSS VSS nfet_03v3 ad=0.1397p pd=1.22u as=0.1108p ps=1.1u w=0.22u l=0.28u
X1497 VSS a_4586_29515# a_4555_29009# VSS nfet_03v3 ad=0.1108p pd=1.1u as=0.139p ps=1.215u w=0.22u l=0.28u
X1498 RBL[139] a_3933_19145# VSS VSS nfet_03v3 ad=0.1516p pd=1.64u as=0.1516p ps=1.64u w=0.22u l=0.28u
X1499 a_5177_21337# WL[19] WBLB[5] VSS nfet_03v3 ad=0.139p pd=1.215u as=0.2362p ps=2.03u w=0.32u l=0.28u
X1500 RBL[164] a_4555_22433# VSS VSS nfet_03v3 ad=0.1516p pd=1.64u as=0.1516p ps=1.64u w=0.22u l=0.28u
X1501 RBL[156] a_4555_21337# VSS VSS nfet_03v3 ad=0.1516p pd=1.64u as=0.1516p ps=1.64u w=0.22u l=0.28u
X1502 RBL[167] a_6421_22433# A[20] VDD pfet_03v3 ad=0.2082p pd=1.84u as=0.2024p ps=1.8u w=0.44u l=0.28u
X1503 VDD a_5208_24035# a_5177_23529# VDD pfet_03v3 ad=0.1496p pd=1.12u as=0.1936p ps=1.76u w=0.44u l=0.28u
X1504 VDD a_5208_22939# a_5177_22433# VDD pfet_03v3 ad=0.1496p pd=1.12u as=0.1936p ps=1.76u w=0.44u l=0.28u
X1505 a_5208_30611# a_5177_30105# VSS VSS nfet_03v3 ad=0.1397p pd=1.22u as=0.1108p ps=1.1u w=0.22u l=0.28u
X1506 VSS a_3342_18555# a_3311_18049# VSS nfet_03v3 ad=0.1108p pd=1.1u as=0.139p ps=1.215u w=0.22u l=0.28u
X1507 VSS a_3342_19651# a_3311_19145# VSS nfet_03v3 ad=0.1108p pd=1.1u as=0.139p ps=1.215u w=0.22u l=0.28u
X1508 VDD a_3342_27323# a_3311_26817# VDD pfet_03v3 ad=0.1496p pd=1.12u as=0.1936p ps=1.76u w=0.44u l=0.28u
X1509 RBL[242] a_3342_33899# A[30] VSS nfet_03v3 ad=0.1516p pd=1.64u as=0.1516p ps=1.64u w=0.22u l=0.28u
X1510 RBL[20] a_4555_2705# VSS VSS nfet_03v3 ad=0.1516p pd=1.64u as=0.1516p ps=1.64u w=0.22u l=0.28u
X1511 VDD a_3964_11979# a_3933_11473# VDD pfet_03v3 ad=0.1496p pd=1.12u as=0.1936p ps=1.76u w=0.44u l=0.28u
X1512 VDD a_3964_13075# a_3933_12569# VDD pfet_03v3 ad=0.1496p pd=1.12u as=0.1936p ps=1.76u w=0.44u l=0.28u
X1513 VSS a_5830_18555# a_5799_18049# VSS nfet_03v3 ad=0.1108p pd=1.1u as=0.139p ps=1.215u w=0.22u l=0.28u
X1514 VSS a_5830_19651# a_5799_19145# VSS nfet_03v3 ad=0.1108p pd=1.1u as=0.139p ps=1.215u w=0.22u l=0.28u
X1515 VDD a_5830_27323# a_5799_26817# VDD pfet_03v3 ad=0.1496p pd=1.12u as=0.1936p ps=1.76u w=0.44u l=0.28u
X1516 RBL[202] a_3311_27913# A[25] VDD pfet_03v3 ad=0.2082p pd=1.84u as=0.2024p ps=1.8u w=0.44u l=0.28u
X1517 RBL[179] a_3933_24625# A[22] VDD pfet_03v3 ad=0.2082p pd=1.84u as=0.2024p ps=1.8u w=0.44u l=0.28u
X1518 RBL[100] a_4555_13665# A[12] VDD pfet_03v3 ad=0.2082p pd=1.84u as=0.2024p ps=1.8u w=0.44u l=0.28u
X1519 a_5830_26227# a_5799_25721# VDD VDD pfet_03v3 ad=0.1936p pd=1.76u as=0.1496p ps=1.12u w=0.44u l=0.28u
X1520 a_5830_16363# a_5799_15857# VSS VSS nfet_03v3 ad=0.1397p pd=1.22u as=0.1108p ps=1.1u w=0.22u l=0.28u
X1521 a_5830_17459# a_5799_16953# VSS VSS nfet_03v3 ad=0.1397p pd=1.22u as=0.1108p ps=1.1u w=0.22u l=0.28u
X1522 a_4586_6499# WL[5] WBL[4] VSS nfet_03v3 ad=0.1397p pd=1.22u as=0.1706p ps=1.7u w=0.32u l=0.28u
X1523 a_5830_5403# a_5799_4897# VSS VSS nfet_03v3 ad=0.1397p pd=1.22u as=0.1108p ps=1.1u w=0.22u l=0.28u
X1524 a_4586_5403# WL[4] WBL[4] VSS nfet_03v3 ad=0.1397p pd=1.22u as=0.1706p ps=1.7u w=0.32u l=0.28u
X1525 a_3933_15857# WL[14] WBLB[3] VSS nfet_03v3 ad=0.139p pd=1.215u as=0.2362p ps=2.03u w=0.32u l=0.28u
X1526 a_3933_16953# WL[15] WBLB[3] VSS nfet_03v3 ad=0.139p pd=1.215u as=0.2362p ps=2.03u w=0.32u l=0.28u
X1527 VDD a_5208_2115# a_5177_1609# VDD pfet_03v3 ad=0.1496p pd=1.12u as=0.1936p ps=1.76u w=0.44u l=0.28u
X1528 RBL[120] a_2067_16953# A[15] VDD pfet_03v3 ad=0.2082p pd=1.84u as=0.2024p ps=1.8u w=0.44u l=0.28u
X1529 a_2720_8691# WL[7] WBL[1] VSS nfet_03v3 ad=0.1397p pd=1.22u as=0.1706p ps=1.7u w=0.32u l=0.28u
X1530 a_2720_9787# WL[8] WBL[1] VSS nfet_03v3 ad=0.1397p pd=1.22u as=0.1706p ps=1.7u w=0.32u l=0.28u
X1531 RBL[3] a_3933_513# A[0] VDD pfet_03v3 ad=0.2082p pd=1.84u as=0.2024p ps=1.8u w=0.44u l=0.28u
X1532 a_2689_22433# WL[20] WBLB[1] VSS nfet_03v3 ad=0.139p pd=1.215u as=0.2362p ps=2.03u w=0.32u l=0.28u
X1533 a_2067_33393# WL[30] WBLB[0] VSS nfet_03v3 ad=0.139p pd=1.215u as=0.2362p ps=2.03u w=0.32u l=0.28u
X1534 a_2067_32297# WL[29] WBLB[0] VSS nfet_03v3 ad=0.139p pd=1.215u as=0.2362p ps=2.03u w=0.32u l=0.28u
X1535 VDD a_2098_34995# a_2067_34489# VDD pfet_03v3 ad=0.1496p pd=1.12u as=0.1936p ps=1.76u w=0.44u l=0.28u
X1536 VSS a_2098_26227# a_2067_25721# VSS nfet_03v3 ad=0.1108p pd=1.1u as=0.139p ps=1.215u w=0.22u l=0.28u
X1537 a_5208_1019# a_5177_513# VSS VSS nfet_03v3 ad=0.1397p pd=1.22u as=0.1108p ps=1.1u w=0.22u l=0.28u
X1538 RBL[101] a_5177_13665# A[12] VDD pfet_03v3 ad=0.2082p pd=1.84u as=0.2024p ps=1.8u w=0.44u l=0.28u
X1539 VDD a_2098_33899# a_2067_33393# VDD pfet_03v3 ad=0.1496p pd=1.12u as=0.1936p ps=1.76u w=0.44u l=0.28u
X1540 VDD a_6452_25131# a_6421_24625# VDD pfet_03v3 ad=0.1496p pd=1.12u as=0.1936p ps=1.76u w=0.44u l=0.28u
X1541 a_2689_5993# WL[5] WBLB[1] VSS nfet_03v3 ad=0.139p pd=1.215u as=0.2362p ps=2.03u w=0.32u l=0.28u
X1542 a_2689_4897# WL[4] WBLB[1] VSS nfet_03v3 ad=0.139p pd=1.215u as=0.2362p ps=2.03u w=0.32u l=0.28u
X1543 RBL[223] a_6452_30611# A[27] VSS nfet_03v3 ad=0.1516p pd=1.64u as=0.1516p ps=1.64u w=0.22u l=0.28u
X1544 a_3964_30611# WL[27] WBL[3] VSS nfet_03v3 ad=0.1397p pd=1.22u as=0.1706p ps=1.7u w=0.32u l=0.28u
X1545 RBL[11] a_3933_1609# VSS VSS nfet_03v3 ad=0.1516p pd=1.64u as=0.1516p ps=1.64u w=0.22u l=0.28u
X1546 VSS a_5208_21843# a_5177_21337# VSS nfet_03v3 ad=0.1108p pd=1.1u as=0.139p ps=1.215u w=0.22u l=0.28u
X1547 VSS a_5208_22939# a_5177_22433# VSS nfet_03v3 ad=0.1108p pd=1.1u as=0.139p ps=1.215u w=0.22u l=0.28u
X1548 VDD a_5208_31707# a_5177_31201# VDD pfet_03v3 ad=0.1496p pd=1.12u as=0.1936p ps=1.76u w=0.44u l=0.28u
X1549 VDD a_5208_30611# a_5177_30105# VDD pfet_03v3 ad=0.1496p pd=1.12u as=0.1936p ps=1.76u w=0.44u l=0.28u
X1550 a_6421_7089# WL[6] WBLB[7] VSS nfet_03v3 ad=0.139p pd=1.215u as=0.2362p ps=2.03u w=0.32u l=0.28u
X1551 VSS a_3964_10883# a_3933_10377# VSS nfet_03v3 ad=0.1108p pd=1.1u as=0.139p ps=1.215u w=0.22u l=0.28u
X1552 VSS a_3964_11979# a_3933_11473# VSS nfet_03v3 ad=0.1108p pd=1.1u as=0.139p ps=1.215u w=0.22u l=0.28u
X1553 a_2098_20747# a_2067_20241# VDD VDD pfet_03v3 ad=0.1936p pd=1.76u as=0.1496p ps=1.12u w=0.44u l=0.28u
X1554 RBL[25] a_2720_4307# A[3] VSS nfet_03v3 ad=0.1516p pd=1.64u as=0.1516p ps=1.64u w=0.22u l=0.28u
X1555 VDD a_4586_16363# a_4555_15857# VDD pfet_03v3 ad=0.1496p pd=1.12u as=0.1936p ps=1.76u w=0.44u l=0.28u
X1556 a_3964_29515# a_3933_29009# VDD VDD pfet_03v3 ad=0.1936p pd=1.76u as=0.1496p ps=1.12u w=0.44u l=0.28u
X1557 RBL[216] a_2067_30105# VSS VSS nfet_03v3 ad=0.1516p pd=1.64u as=0.1516p ps=1.64u w=0.22u l=0.28u
X1558 a_3964_28419# a_3933_27913# VDD VDD pfet_03v3 ad=0.1936p pd=1.76u as=0.1496p ps=1.12u w=0.44u l=0.28u
X1559 RBL[156] a_4586_21843# A[19] VSS nfet_03v3 ad=0.1516p pd=1.64u as=0.1516p ps=1.64u w=0.22u l=0.28u
X1560 RBL[164] a_4586_22939# A[20] VSS nfet_03v3 ad=0.1516p pd=1.64u as=0.1516p ps=1.64u w=0.22u l=0.28u
X1561 a_5799_31201# WL[28] WBLB[6] VSS nfet_03v3 ad=0.139p pd=1.215u as=0.2362p ps=2.03u w=0.32u l=0.28u
X1562 RBL[220] a_4555_30105# VSS VSS nfet_03v3 ad=0.1516p pd=1.64u as=0.1516p ps=1.64u w=0.22u l=0.28u
X1563 RBL[74] a_3342_10883# A[9] VSS nfet_03v3 ad=0.1516p pd=1.64u as=0.1516p ps=1.64u w=0.22u l=0.28u
X1564 RBL[82] a_3342_11979# A[10] VSS nfet_03v3 ad=0.1516p pd=1.64u as=0.1516p ps=1.64u w=0.22u l=0.28u
X1565 a_3933_23529# WL[21] WBLB[3] VSS nfet_03v3 ad=0.139p pd=1.215u as=0.2362p ps=2.03u w=0.32u l=0.28u
X1566 VSS a_5208_7595# a_5177_7089# VSS nfet_03v3 ad=0.1108p pd=1.1u as=0.139p ps=1.215u w=0.22u l=0.28u
X1567 VSS a_3342_28419# a_3311_27913# VSS nfet_03v3 ad=0.1108p pd=1.1u as=0.139p ps=1.215u w=0.22u l=0.28u
X1568 VSS a_3342_27323# a_3311_26817# VSS nfet_03v3 ad=0.1108p pd=1.1u as=0.139p ps=1.215u w=0.22u l=0.28u
X1569 RBL[227] a_3964_31707# A[28] VSS nfet_03v3 ad=0.1516p pd=1.64u as=0.1516p ps=1.64u w=0.22u l=0.28u
X1570 VSS a_5830_28419# a_5799_27913# VSS nfet_03v3 ad=0.1108p pd=1.1u as=0.139p ps=1.215u w=0.22u l=0.28u
X1571 VSS a_5830_27323# a_5799_26817# VSS nfet_03v3 ad=0.1108p pd=1.1u as=0.139p ps=1.215u w=0.22u l=0.28u
X1572 VDD a_6452_32803# a_6421_32297# VDD pfet_03v3 ad=0.1496p pd=1.12u as=0.1936p ps=1.76u w=0.44u l=0.28u
X1573 VSS a_6452_25131# a_6421_24625# VSS nfet_03v3 ad=0.1108p pd=1.1u as=0.139p ps=1.215u w=0.22u l=0.28u
X1574 VSS a_6452_24035# a_6421_23529# VSS nfet_03v3 ad=0.1108p pd=1.1u as=0.139p ps=1.215u w=0.22u l=0.28u
X1575 RBL[164] a_4555_22433# A[20] VDD pfet_03v3 ad=0.2082p pd=1.84u as=0.2024p ps=1.8u w=0.44u l=0.28u
X1576 RBL[243] a_3933_33393# A[30] VDD pfet_03v3 ad=0.2082p pd=1.84u as=0.2024p ps=1.8u w=0.44u l=0.28u
X1577 RBL[201] a_2720_28419# A[25] VSS nfet_03v3 ad=0.1516p pd=1.64u as=0.1516p ps=1.64u w=0.22u l=0.28u
X1578 RBL[193] a_2720_27323# A[24] VSS nfet_03v3 ad=0.1516p pd=1.64u as=0.1516p ps=1.64u w=0.22u l=0.28u
X1579 a_2098_5403# a_2067_4897# VDD VDD pfet_03v3 ad=0.1936p pd=1.76u as=0.1496p ps=1.12u w=0.44u l=0.28u
X1580 a_3342_21843# WL[19] WBL[2] VSS nfet_03v3 ad=0.1397p pd=1.22u as=0.1706p ps=1.7u w=0.32u l=0.28u
X1581 a_3342_30611# a_3311_30105# VSS VSS nfet_03v3 ad=0.1397p pd=1.22u as=0.1108p ps=1.1u w=0.22u l=0.28u
X1582 a_2067_10377# WL[9] WBLB[0] VSS nfet_03v3 ad=0.139p pd=1.215u as=0.2362p ps=2.03u w=0.32u l=0.28u
X1583 a_2067_11473# WL[10] WBLB[0] VSS nfet_03v3 ad=0.139p pd=1.215u as=0.2362p ps=2.03u w=0.32u l=0.28u
X1584 VDD a_2098_13075# a_2067_12569# VDD pfet_03v3 ad=0.1496p pd=1.12u as=0.1936p ps=1.76u w=0.44u l=0.28u
X1585 VDD a_2098_11979# a_2067_11473# VDD pfet_03v3 ad=0.1496p pd=1.12u as=0.1936p ps=1.76u w=0.44u l=0.28u
X1586 a_5830_16363# WL[14] WBL[6] VSS nfet_03v3 ad=0.1397p pd=1.22u as=0.1706p ps=1.7u w=0.32u l=0.28u
X1587 a_5830_17459# WL[15] WBL[6] VSS nfet_03v3 ad=0.1397p pd=1.22u as=0.1706p ps=1.7u w=0.32u l=0.28u
X1588 RBL[174] a_5830_24035# A[21] VSS nfet_03v3 ad=0.1516p pd=1.64u as=0.1516p ps=1.64u w=0.22u l=0.28u
X1589 VDD a_3342_2115# a_3311_1609# VDD pfet_03v3 ad=0.1496p pd=1.12u as=0.1936p ps=1.76u w=0.44u l=0.28u
X1590 RBL[165] a_5177_22433# A[20] VDD pfet_03v3 ad=0.2082p pd=1.84u as=0.2024p ps=1.8u w=0.44u l=0.28u
X1591 a_5830_1019# a_5799_513# VDD VDD pfet_03v3 ad=0.1936p pd=1.76u as=0.1496p ps=1.12u w=0.44u l=0.28u
X1592 RBL[19] a_3933_2705# A[2] VDD pfet_03v3 ad=0.2082p pd=1.84u as=0.2024p ps=1.8u w=0.44u l=0.28u
X1593 RBL[11] a_3933_1609# A[1] VDD pfet_03v3 ad=0.2082p pd=1.84u as=0.2024p ps=1.8u w=0.44u l=0.28u
X1594 VSS a_5208_1019# a_5177_513# VSS nfet_03v3 ad=0.1108p pd=1.1u as=0.139p ps=1.215u w=0.22u l=0.28u
X1595 RBL[98] a_3311_13665# A[12] VDD pfet_03v3 ad=0.2082p pd=1.84u as=0.2024p ps=1.8u w=0.44u l=0.28u
X1596 RBL[8] a_2098_2115# A[1] VSS nfet_03v3 ad=0.1516p pd=1.64u as=0.1516p ps=1.64u w=0.22u l=0.28u
X1597 VDD a_4586_25131# a_4555_24625# VDD pfet_03v3 ad=0.1496p pd=1.12u as=0.1936p ps=1.76u w=0.44u l=0.28u
X1598 RBL[8] a_2067_1609# VSS VSS nfet_03v3 ad=0.1516p pd=1.64u as=0.1516p ps=1.64u w=0.22u l=0.28u
X1599 RBL[220] a_4586_30611# A[27] VSS nfet_03v3 ad=0.1516p pd=1.64u as=0.1516p ps=1.64u w=0.22u l=0.28u
X1600 a_5830_17459# a_5799_16953# VDD VDD pfet_03v3 ad=0.1936p pd=1.76u as=0.1496p ps=1.12u w=0.44u l=0.28u
X1601 a_5830_18555# a_5799_18049# VDD VDD pfet_03v3 ad=0.1936p pd=1.76u as=0.1496p ps=1.12u w=0.44u l=0.28u
X1602 RBL[135] a_6421_18049# VSS VSS nfet_03v3 ad=0.1516p pd=1.64u as=0.1516p ps=1.64u w=0.22u l=0.28u
X1603 RBL[249] a_2720_34995# A[31] VSS nfet_03v3 ad=0.1516p pd=1.64u as=0.1516p ps=1.64u w=0.22u l=0.28u
X1604 RBL[214] a_5799_29009# VSS VSS nfet_03v3 ad=0.1516p pd=1.64u as=0.1516p ps=1.64u w=0.22u l=0.28u
X1605 a_2720_28419# WL[25] WBL[1] VSS nfet_03v3 ad=0.1397p pd=1.22u as=0.1706p ps=1.7u w=0.32u l=0.28u
X1606 a_2720_27323# WL[24] WBL[1] VSS nfet_03v3 ad=0.1397p pd=1.22u as=0.1706p ps=1.7u w=0.32u l=0.28u
X1607 RBL[33] a_2689_4897# A[4] VDD pfet_03v3 ad=0.2082p pd=1.84u as=0.2024p ps=1.8u w=0.44u l=0.28u
X1608 RBL[25] a_2689_3801# A[3] VDD pfet_03v3 ad=0.2082p pd=1.84u as=0.2024p ps=1.8u w=0.44u l=0.28u
X1609 VDD a_3342_14171# a_3311_13665# VDD pfet_03v3 ad=0.1496p pd=1.12u as=0.1936p ps=1.76u w=0.44u l=0.28u
X1610 RBL[146] a_3342_20747# A[18] VSS nfet_03v3 ad=0.1516p pd=1.64u as=0.1516p ps=1.64u w=0.22u l=0.28u
X1611 RBL[209] a_2689_29009# A[26] VDD pfet_03v3 ad=0.2082p pd=1.84u as=0.2024p ps=1.8u w=0.44u l=0.28u
X1612 RBL[47] a_6421_5993# A[5] VDD pfet_03v3 ad=0.2082p pd=1.84u as=0.2024p ps=1.8u w=0.44u l=0.28u
X1613 VDD a_3964_8691# a_3933_8185# VDD pfet_03v3 ad=0.1496p pd=1.12u as=0.1936p ps=1.76u w=0.44u l=0.28u
X1614 VDD a_3964_9787# a_3933_9281# VDD pfet_03v3 ad=0.1496p pd=1.12u as=0.1936p ps=1.76u w=0.44u l=0.28u
X1615 VSS a_2098_10883# a_2067_10377# VSS nfet_03v3 ad=0.1108p pd=1.1u as=0.139p ps=1.215u w=0.22u l=0.28u
X1616 VSS a_2098_11979# a_2067_11473# VSS nfet_03v3 ad=0.1108p pd=1.1u as=0.139p ps=1.215u w=0.22u l=0.28u
X1617 VDD a_5830_4307# a_5799_3801# VDD pfet_03v3 ad=0.1496p pd=1.12u as=0.1936p ps=1.76u w=0.44u l=0.28u
X1618 VDD a_5830_14171# a_5799_13665# VDD pfet_03v3 ad=0.1496p pd=1.12u as=0.1936p ps=1.76u w=0.44u l=0.28u
X1619 a_5830_24035# WL[21] WBL[6] VSS nfet_03v3 ad=0.1397p pd=1.22u as=0.1706p ps=1.7u w=0.32u l=0.28u
X1620 VSS a_5830_1019# a_5799_513# VSS nfet_03v3 ad=0.1108p pd=1.1u as=0.139p ps=1.215u w=0.22u l=0.28u
X1621 VDD a_6452_10883# a_6421_10377# VDD pfet_03v3 ad=0.1496p pd=1.12u as=0.1936p ps=1.76u w=0.44u l=0.28u
X1622 a_6452_19651# a_6421_19145# VDD VDD pfet_03v3 ad=0.1936p pd=1.76u as=0.1496p ps=1.12u w=0.44u l=0.28u
X1623 VSS a_3342_7595# a_3311_7089# VSS nfet_03v3 ad=0.1108p pd=1.1u as=0.139p ps=1.215u w=0.22u l=0.28u
X1624 a_3964_6499# a_3933_5993# VDD VDD pfet_03v3 ad=0.1936p pd=1.76u as=0.1496p ps=1.12u w=0.44u l=0.28u
X1625 a_3964_7595# a_3933_7089# VDD VDD pfet_03v3 ad=0.1936p pd=1.76u as=0.1496p ps=1.12u w=0.44u l=0.28u
X1626 a_2098_5403# a_2067_4897# VSS VSS nfet_03v3 ad=0.1397p pd=1.22u as=0.1108p ps=1.1u w=0.22u l=0.28u
X1627 a_4555_31201# WL[28] WBLB[4] VSS nfet_03v3 ad=0.139p pd=1.215u as=0.2362p ps=2.03u w=0.32u l=0.28u
X1628 VSS a_4586_25131# a_4555_24625# VSS nfet_03v3 ad=0.1108p pd=1.1u as=0.139p ps=1.215u w=0.22u l=0.28u
X1629 a_3342_6499# WL[5] WBL[2] VSS nfet_03v3 ad=0.1397p pd=1.22u as=0.1706p ps=1.7u w=0.32u l=0.28u
X1630 a_3342_5403# WL[4] WBL[2] VSS nfet_03v3 ad=0.1397p pd=1.22u as=0.1706p ps=1.7u w=0.32u l=0.28u
X1631 a_2720_1019# WL[0] WBL[1] VSS nfet_03v3 ad=0.1397p pd=1.22u as=0.1706p ps=1.7u w=0.32u l=0.28u
X1632 VSS a_4586_24035# a_4555_23529# VSS nfet_03v3 ad=0.1108p pd=1.1u as=0.139p ps=1.215u w=0.22u l=0.28u
X1633 VSS a_3964_34995# a_3933_34489# VSS nfet_03v3 ad=0.1108p pd=1.1u as=0.139p ps=1.215u w=0.22u l=0.28u
X1634 VDD a_4586_32803# a_4555_32297# VDD pfet_03v3 ad=0.1496p pd=1.12u as=0.1936p ps=1.76u w=0.44u l=0.28u
X1635 a_2720_8691# a_2689_8185# VDD VDD pfet_03v3 ad=0.1936p pd=1.76u as=0.1496p ps=1.12u w=0.44u l=0.28u
X1636 a_2720_9787# a_2689_9281# VDD VDD pfet_03v3 ad=0.1936p pd=1.76u as=0.1496p ps=1.12u w=0.44u l=0.28u
X1637 a_5830_6499# a_5799_5993# VSS VSS nfet_03v3 ad=0.1397p pd=1.22u as=0.1108p ps=1.1u w=0.22u l=0.28u
X1638 VDD a_2720_26227# a_2689_25721# VDD pfet_03v3 ad=0.1496p pd=1.12u as=0.1936p ps=1.76u w=0.44u l=0.28u
X1639 VSS a_2720_16363# a_2689_15857# VSS nfet_03v3 ad=0.1108p pd=1.1u as=0.139p ps=1.215u w=0.22u l=0.28u
X1640 VSS a_2720_17459# a_2689_16953# VSS nfet_03v3 ad=0.1108p pd=1.1u as=0.139p ps=1.215u w=0.22u l=0.28u
X1641 a_6452_29515# WL[26] WBL[7] VSS nfet_03v3 ad=0.1397p pd=1.22u as=0.1706p ps=1.7u w=0.32u l=0.28u
X1642 VSS a_3342_13075# a_3311_12569# VSS nfet_03v3 ad=0.1108p pd=1.1u as=0.139p ps=1.215u w=0.22u l=0.28u
X1643 VSS a_3342_14171# a_3311_13665# VSS nfet_03v3 ad=0.1108p pd=1.1u as=0.139p ps=1.215u w=0.22u l=0.28u
X1644 RBL[171] a_3964_24035# A[21] VSS nfet_03v3 ad=0.1516p pd=1.64u as=0.1516p ps=1.64u w=0.22u l=0.28u
X1645 RBL[4] a_4555_513# A[0] VDD pfet_03v3 ad=0.2082p pd=1.84u as=0.2024p ps=1.8u w=0.44u l=0.28u
X1646 VSS a_3964_8691# a_3933_8185# VSS nfet_03v3 ad=0.1108p pd=1.1u as=0.139p ps=1.215u w=0.22u l=0.28u
X1647 RBL[37] a_5177_4897# VSS VSS nfet_03v3 ad=0.1516p pd=1.64u as=0.1516p ps=1.64u w=0.22u l=0.28u
X1648 RBL[45] a_5177_5993# VSS VSS nfet_03v3 ad=0.1516p pd=1.64u as=0.1516p ps=1.64u w=0.22u l=0.28u
X1649 VSS a_5830_13075# a_5799_12569# VSS nfet_03v3 ad=0.1108p pd=1.1u as=0.139p ps=1.215u w=0.22u l=0.28u
X1650 VSS a_5830_14171# a_5799_13665# VSS nfet_03v3 ad=0.1108p pd=1.1u as=0.139p ps=1.215u w=0.22u l=0.28u
X1651 RBL[162] a_3311_22433# A[20] VDD pfet_03v3 ad=0.2082p pd=1.84u as=0.2024p ps=1.8u w=0.44u l=0.28u
X1652 RBL[89] a_2720_13075# A[11] VSS nfet_03v3 ad=0.1516p pd=1.64u as=0.1516p ps=1.64u w=0.22u l=0.28u
X1653 a_6452_18555# a_6421_18049# VSS VSS nfet_03v3 ad=0.1397p pd=1.22u as=0.1108p ps=1.1u w=0.22u l=0.28u
X1654 a_6452_19651# a_6421_19145# VSS VSS nfet_03v3 ad=0.1397p pd=1.22u as=0.1108p ps=1.1u w=0.22u l=0.28u
X1655 a_6452_27323# a_6421_26817# VDD VDD pfet_03v3 ad=0.1936p pd=1.76u as=0.1496p ps=1.12u w=0.44u l=0.28u
X1656 VDD a_2098_9787# a_2067_9281# VDD pfet_03v3 ad=0.1496p pd=1.12u as=0.1936p ps=1.76u w=0.44u l=0.28u
X1657 RBL[44] a_4555_5993# A[5] VDD pfet_03v3 ad=0.2082p pd=1.84u as=0.2024p ps=1.8u w=0.44u l=0.28u
X1658 a_5177_7089# WL[6] WBLB[5] VSS nfet_03v3 ad=0.139p pd=1.215u as=0.2362p ps=2.03u w=0.32u l=0.28u
X1659 VDD a_2098_8691# a_2067_8185# VDD pfet_03v3 ad=0.1496p pd=1.12u as=0.1936p ps=1.76u w=0.44u l=0.28u
X1660 RBL[80] a_2067_11473# A[10] VDD pfet_03v3 ad=0.2082p pd=1.84u as=0.2024p ps=1.8u w=0.44u l=0.28u
X1661 a_3342_1019# WL[0] WBL[2] VSS nfet_03v3 ad=0.1397p pd=1.22u as=0.1706p ps=1.7u w=0.32u l=0.28u
X1662 RBL[222] a_5799_30105# A[27] VDD pfet_03v3 ad=0.2082p pd=1.84u as=0.2024p ps=1.8u w=0.44u l=0.28u
X1663 a_2720_4307# WL[3] WBL[1] VSS nfet_03v3 ad=0.1397p pd=1.22u as=0.1706p ps=1.7u w=0.32u l=0.28u
X1664 a_2720_3211# WL[2] WBL[1] VSS nfet_03v3 ad=0.1397p pd=1.22u as=0.1706p ps=1.7u w=0.32u l=0.28u
X1665 VSS a_2720_9787# a_2689_9281# VSS nfet_03v3 ad=0.1108p pd=1.1u as=0.139p ps=1.215u w=0.22u l=0.28u
X1666 a_3311_20241# WL[18] WBLB[2] VSS nfet_03v3 ad=0.139p pd=1.215u as=0.2362p ps=2.03u w=0.32u l=0.28u
X1667 VSS a_5830_4307# a_5799_3801# VSS nfet_03v3 ad=0.1108p pd=1.1u as=0.139p ps=1.215u w=0.22u l=0.28u
X1668 a_2720_31707# a_2689_31201# VSS VSS nfet_03v3 ad=0.1397p pd=1.22u as=0.1108p ps=1.1u w=0.22u l=0.28u
X1669 RBL[211] a_3933_29009# VSS VSS nfet_03v3 ad=0.1516p pd=1.64u as=0.1516p ps=1.64u w=0.22u l=0.28u
X1670 a_2720_8691# a_2689_8185# VSS VSS nfet_03v3 ad=0.1397p pd=1.22u as=0.1108p ps=1.1u w=0.22u l=0.28u
X1671 a_5208_18555# WL[16] WBL[5] VSS nfet_03v3 ad=0.1397p pd=1.22u as=0.1706p ps=1.7u w=0.32u l=0.28u
X1672 RBL[239] a_6421_32297# A[29] VDD pfet_03v3 ad=0.2082p pd=1.84u as=0.2024p ps=1.8u w=0.44u l=0.28u
X1673 RBL[231] a_6421_31201# A[28] VDD pfet_03v3 ad=0.2082p pd=1.84u as=0.2024p ps=1.8u w=0.44u l=0.28u
X1674 a_6452_9787# a_6421_9281# VSS VSS nfet_03v3 ad=0.1397p pd=1.22u as=0.1108p ps=1.1u w=0.22u l=0.28u
X1675 RBL[129] a_2689_18049# VSS VSS nfet_03v3 ad=0.1516p pd=1.64u as=0.1516p ps=1.64u w=0.22u l=0.28u
X1676 VDD a_4586_10883# a_4555_10377# VDD pfet_03v3 ad=0.1496p pd=1.12u as=0.1936p ps=1.76u w=0.44u l=0.28u
X1677 VDD a_3964_21843# a_3933_21337# VDD pfet_03v3 ad=0.1496p pd=1.12u as=0.1936p ps=1.76u w=0.44u l=0.28u
X1678 a_5208_7595# WL[6] WBL[5] VSS nfet_03v3 ad=0.1397p pd=1.22u as=0.1706p ps=1.7u w=0.32u l=0.28u
X1679 a_3964_15267# a_3933_14761# VSS VSS nfet_03v3 ad=0.1397p pd=1.22u as=0.1108p ps=1.1u w=0.22u l=0.28u
X1680 a_4586_19651# a_4555_19145# VDD VDD pfet_03v3 ad=0.1936p pd=1.76u as=0.1496p ps=1.12u w=0.44u l=0.28u
X1681 RBL[102] a_5799_13665# VSS VSS nfet_03v3 ad=0.1516p pd=1.64u as=0.1516p ps=1.64u w=0.22u l=0.28u
X1682 RBL[110] a_5799_14761# VSS VSS nfet_03v3 ad=0.1516p pd=1.64u as=0.1516p ps=1.64u w=0.22u l=0.28u
X1683 a_2720_19651# WL[17] WBL[1] VSS nfet_03v3 ad=0.1397p pd=1.22u as=0.1706p ps=1.7u w=0.32u l=0.28u
X1684 VSS a_2098_8691# a_2067_8185# VSS nfet_03v3 ad=0.1108p pd=1.1u as=0.139p ps=1.215u w=0.22u l=0.28u
X1685 a_5830_26227# a_5799_25721# VSS VSS nfet_03v3 ad=0.1397p pd=1.22u as=0.1108p ps=1.1u w=0.22u l=0.28u
X1686 RBL[34] a_3311_4897# VSS VSS nfet_03v3 ad=0.1516p pd=1.64u as=0.1516p ps=1.64u w=0.22u l=0.28u
X1687 RBL[42] a_3311_5993# VSS VSS nfet_03v3 ad=0.1516p pd=1.64u as=0.1516p ps=1.64u w=0.22u l=0.28u
X1688 a_5830_34995# a_5799_34489# VDD VDD pfet_03v3 ad=0.1936p pd=1.76u as=0.1496p ps=1.12u w=0.44u l=0.28u
X1689 a_5830_33899# a_5799_33393# VDD VDD pfet_03v3 ad=0.1936p pd=1.76u as=0.1496p ps=1.12u w=0.44u l=0.28u
X1690 VSS a_5208_3211# a_5177_2705# VSS nfet_03v3 ad=0.1108p pd=1.1u as=0.139p ps=1.215u w=0.22u l=0.28u
X1691 VSS a_5208_2115# a_5177_1609# VSS nfet_03v3 ad=0.1108p pd=1.1u as=0.139p ps=1.215u w=0.22u l=0.28u
X1692 RBL[105] a_2689_14761# A[13] VDD pfet_03v3 ad=0.2082p pd=1.84u as=0.2024p ps=1.8u w=0.44u l=0.28u
X1693 RBL[113] a_2689_15857# A[14] VDD pfet_03v3 ad=0.2082p pd=1.84u as=0.2024p ps=1.8u w=0.44u l=0.28u
X1694 RBL[192] a_2067_26817# A[24] VDD pfet_03v3 ad=0.2082p pd=1.84u as=0.2024p ps=1.8u w=0.44u l=0.28u
X1695 RBL[184] a_2067_25721# A[23] VDD pfet_03v3 ad=0.2082p pd=1.84u as=0.2024p ps=1.8u w=0.44u l=0.28u
X1696 a_5208_19651# a_5177_19145# VDD VDD pfet_03v3 ad=0.1936p pd=1.76u as=0.1496p ps=1.12u w=0.44u l=0.28u
X1697 a_2689_31201# WL[28] WBLB[1] VSS nfet_03v3 ad=0.139p pd=1.215u as=0.2362p ps=2.03u w=0.32u l=0.28u
X1698 VSS a_2098_34995# a_2067_34489# VSS nfet_03v3 ad=0.1108p pd=1.1u as=0.139p ps=1.215u w=0.22u l=0.28u
X1699 a_2098_29515# WL[26] WBL[0] VSS nfet_03v3 ad=0.1397p pd=1.22u as=0.1706p ps=1.7u w=0.32u l=0.28u
X1700 a_6452_28419# a_6421_27913# VSS VSS nfet_03v3 ad=0.1397p pd=1.22u as=0.1108p ps=1.1u w=0.22u l=0.28u
X1701 a_6452_27323# a_6421_26817# VSS VSS nfet_03v3 ad=0.1397p pd=1.22u as=0.1108p ps=1.1u w=0.22u l=0.28u
X1702 a_5208_26227# WL[23] WBL[5] VSS nfet_03v3 ad=0.1397p pd=1.22u as=0.1706p ps=1.7u w=0.32u l=0.28u
X1703 a_5208_25131# WL[22] WBL[5] VSS nfet_03v3 ad=0.1397p pd=1.22u as=0.1706p ps=1.7u w=0.32u l=0.28u
X1704 RBL[34] a_3342_5403# A[4] VSS nfet_03v3 ad=0.1516p pd=1.64u as=0.1516p ps=1.64u w=0.22u l=0.28u
X1705 RBL[42] a_3342_6499# A[5] VSS nfet_03v3 ad=0.1516p pd=1.64u as=0.1516p ps=1.64u w=0.22u l=0.28u
X1706 VSS a_5208_31707# a_5177_31201# VSS nfet_03v3 ad=0.1108p pd=1.1u as=0.139p ps=1.215u w=0.22u l=0.28u
X1707 VSS a_3964_20747# a_3933_20241# VSS nfet_03v3 ad=0.1108p pd=1.1u as=0.139p ps=1.215u w=0.22u l=0.28u
X1708 a_3964_29515# a_3933_29009# VSS VSS nfet_03v3 ad=0.1397p pd=1.22u as=0.1108p ps=1.1u w=0.22u l=0.28u
X1709 a_4586_27323# a_4555_26817# VDD VDD pfet_03v3 ad=0.1936p pd=1.76u as=0.1496p ps=1.12u w=0.44u l=0.28u
X1710 a_4586_18555# a_4555_18049# VSS VSS nfet_03v3 ad=0.1397p pd=1.22u as=0.1108p ps=1.1u w=0.22u l=0.28u
X1711 a_4586_19651# a_4555_19145# VSS VSS nfet_03v3 ad=0.1397p pd=1.22u as=0.1108p ps=1.1u w=0.22u l=0.28u
X1712 a_4586_9787# a_4555_9281# VSS VSS nfet_03v3 ad=0.1397p pd=1.22u as=0.1108p ps=1.1u w=0.22u l=0.28u
X1713 VDD a_2720_17459# a_2689_16953# VDD pfet_03v3 ad=0.1496p pd=1.12u as=0.1936p ps=1.76u w=0.44u l=0.28u
X1714 VDD a_2720_18555# a_2689_18049# VDD pfet_03v3 ad=0.1496p pd=1.12u as=0.1936p ps=1.76u w=0.44u l=0.28u
X1715 RBL[45] a_5177_5993# A[5] VDD pfet_03v3 ad=0.2082p pd=1.84u as=0.2024p ps=1.8u w=0.44u l=0.28u
X1716 VDD a_3342_15267# a_3311_14761# VDD pfet_03v3 ad=0.1496p pd=1.12u as=0.1936p ps=1.76u w=0.44u l=0.28u
X1717 a_3311_30105# WL[27] WBLB[2] VSS nfet_03v3 ad=0.139p pd=1.215u as=0.2362p ps=2.03u w=0.32u l=0.28u
X1718 a_3933_33393# WL[30] WBLB[3] VSS nfet_03v3 ad=0.139p pd=1.215u as=0.2362p ps=2.03u w=0.32u l=0.28u
X1719 a_3933_32297# WL[29] WBLB[3] VSS nfet_03v3 ad=0.139p pd=1.215u as=0.2362p ps=2.03u w=0.32u l=0.28u
X1720 RBL[62] a_5830_8691# A[7] VSS nfet_03v3 ad=0.1516p pd=1.64u as=0.1516p ps=1.64u w=0.22u l=0.28u
X1721 RBL[70] a_5830_9787# A[8] VSS nfet_03v3 ad=0.1516p pd=1.64u as=0.1516p ps=1.64u w=0.22u l=0.28u
X1722 VDD a_5830_15267# a_5799_14761# VDD pfet_03v3 ad=0.1496p pd=1.12u as=0.1936p ps=1.76u w=0.44u l=0.28u
X1723 a_5208_18555# a_5177_18049# VSS VSS nfet_03v3 ad=0.1397p pd=1.22u as=0.1108p ps=1.1u w=0.22u l=0.28u
X1724 a_5208_19651# a_5177_19145# VSS VSS nfet_03v3 ad=0.1397p pd=1.22u as=0.1108p ps=1.1u w=0.22u l=0.28u
X1725 a_5208_27323# a_5177_26817# VDD VDD pfet_03v3 ad=0.1936p pd=1.76u as=0.1496p ps=1.12u w=0.44u l=0.28u
X1726 a_6421_27913# WL[25] WBLB[7] VSS nfet_03v3 ad=0.139p pd=1.215u as=0.2362p ps=2.03u w=0.32u l=0.28u
X1727 a_6421_26817# WL[24] WBLB[7] VSS nfet_03v3 ad=0.139p pd=1.215u as=0.2362p ps=2.03u w=0.32u l=0.28u
X1728 a_5830_11979# a_5799_11473# VDD VDD pfet_03v3 ad=0.1936p pd=1.76u as=0.1496p ps=1.12u w=0.44u l=0.28u
X1729 a_5830_13075# a_5799_12569# VDD VDD pfet_03v3 ad=0.1936p pd=1.76u as=0.1496p ps=1.12u w=0.44u l=0.28u
X1730 VSS a_6452_33899# a_6421_33393# VSS nfet_03v3 ad=0.1108p pd=1.1u as=0.139p ps=1.215u w=0.22u l=0.28u
X1731 VSS a_6452_32803# a_6421_32297# VSS nfet_03v3 ad=0.1108p pd=1.1u as=0.139p ps=1.215u w=0.22u l=0.28u
X1732 RBL[236] a_4555_32297# A[29] VDD pfet_03v3 ad=0.2082p pd=1.84u as=0.2024p ps=1.8u w=0.44u l=0.28u
X1733 RBL[228] a_4555_31201# A[28] VDD pfet_03v3 ad=0.2082p pd=1.84u as=0.2024p ps=1.8u w=0.44u l=0.28u
X1734 a_2098_6499# a_2067_5993# VSS VSS nfet_03v3 ad=0.1397p pd=1.22u as=0.1108p ps=1.1u w=0.22u l=0.28u
X1735 RBL[169] a_2689_23529# A[21] VDD pfet_03v3 ad=0.2082p pd=1.84u as=0.2024p ps=1.8u w=0.44u l=0.28u
X1736 VDD a_3964_3211# a_3933_2705# VDD pfet_03v3 ad=0.1496p pd=1.12u as=0.1936p ps=1.76u w=0.44u l=0.28u
X1737 a_2067_20241# WL[18] WBLB[0] VSS nfet_03v3 ad=0.139p pd=1.215u as=0.2362p ps=2.03u w=0.32u l=0.28u
X1738 RBL[248] a_2067_34489# A[31] VDD pfet_03v3 ad=0.2082p pd=1.84u as=0.2024p ps=1.8u w=0.44u l=0.28u
X1739 RBL[0] a_2067_513# A[0] VDD pfet_03v3 ad=0.2082p pd=1.84u as=0.2024p ps=1.8u w=0.44u l=0.28u
X1740 VDD a_2098_21843# a_2067_21337# VDD pfet_03v3 ad=0.1496p pd=1.12u as=0.1936p ps=1.76u w=0.44u l=0.28u
X1741 VSS a_6452_1019# a_6421_513# VSS nfet_03v3 ad=0.1108p pd=1.1u as=0.139p ps=1.215u w=0.22u l=0.28u
X1742 a_6452_14171# a_6421_13665# VDD VDD pfet_03v3 ad=0.1936p pd=1.76u as=0.1496p ps=1.12u w=0.44u l=0.28u
X1743 RBL[99] a_3933_13665# VSS VSS nfet_03v3 ad=0.1516p pd=1.64u as=0.1516p ps=1.64u w=0.22u l=0.28u
X1744 RBL[107] a_3933_14761# VSS VSS nfet_03v3 ad=0.1516p pd=1.64u as=0.1516p ps=1.64u w=0.22u l=0.28u
X1745 VSS a_3342_3211# a_3311_2705# VSS nfet_03v3 ad=0.1108p pd=1.1u as=0.139p ps=1.215u w=0.22u l=0.28u
X1746 VSS a_3342_2115# a_3311_1609# VSS nfet_03v3 ad=0.1108p pd=1.1u as=0.139p ps=1.215u w=0.22u l=0.28u
X1747 a_3964_18555# WL[16] WBL[3] VSS nfet_03v3 ad=0.1397p pd=1.22u as=0.1706p ps=1.7u w=0.32u l=0.28u
X1748 RBL[237] a_5177_32297# A[29] VDD pfet_03v3 ad=0.2082p pd=1.84u as=0.2024p ps=1.8u w=0.44u l=0.28u
X1749 RBL[229] a_5177_31201# A[28] VDD pfet_03v3 ad=0.2082p pd=1.84u as=0.2024p ps=1.8u w=0.44u l=0.28u
X1750 a_3964_2115# a_3933_1609# VDD VDD pfet_03v3 ad=0.1936p pd=1.76u as=0.1496p ps=1.12u w=0.44u l=0.28u
X1751 RBL[53] a_5208_7595# A[6] VSS nfet_03v3 ad=0.1516p pd=1.64u as=0.1516p ps=1.64u w=0.22u l=0.28u
X1752 RBL[17] a_2689_2705# VSS VSS nfet_03v3 ad=0.1516p pd=1.64u as=0.1516p ps=1.64u w=0.22u l=0.28u
X1753 RBL[143] a_6452_19651# A[17] VSS nfet_03v3 ad=0.1516p pd=1.64u as=0.1516p ps=1.64u w=0.22u l=0.28u
X1754 a_3342_19651# a_3311_19145# VDD VDD pfet_03v3 ad=0.1936p pd=1.76u as=0.1496p ps=1.12u w=0.44u l=0.28u
X1755 a_3964_16363# a_3933_15857# VDD VDD pfet_03v3 ad=0.1936p pd=1.76u as=0.1496p ps=1.12u w=0.44u l=0.28u
X1756 RBL[42] a_3311_5993# A[5] VDD pfet_03v3 ad=0.2082p pd=1.84u as=0.2024p ps=1.8u w=0.44u l=0.28u
X1757 a_4586_28419# a_4555_27913# VSS VSS nfet_03v3 ad=0.1397p pd=1.22u as=0.1108p ps=1.1u w=0.22u l=0.28u
X1758 a_4586_27323# a_4555_26817# VSS VSS nfet_03v3 ad=0.1397p pd=1.22u as=0.1108p ps=1.1u w=0.22u l=0.28u
X1759 a_2720_3211# a_2689_2705# VDD VDD pfet_03v3 ad=0.1936p pd=1.76u as=0.1496p ps=1.12u w=0.44u l=0.28u
X1760 a_5830_10883# a_5799_10377# VSS VSS nfet_03v3 ad=0.1397p pd=1.22u as=0.1108p ps=1.1u w=0.22u l=0.28u
X1761 a_5830_11979# a_5799_11473# VSS VSS nfet_03v3 ad=0.1397p pd=1.22u as=0.1108p ps=1.1u w=0.22u l=0.28u
X1762 RBL[59] a_3964_8691# A[7] VSS nfet_03v3 ad=0.1516p pd=1.64u as=0.1516p ps=1.64u w=0.22u l=0.28u
X1763 RBL[67] a_3964_9787# A[8] VSS nfet_03v3 ad=0.1516p pd=1.64u as=0.1516p ps=1.64u w=0.22u l=0.28u
X1764 a_3933_11473# WL[10] WBLB[3] VSS nfet_03v3 ad=0.139p pd=1.215u as=0.2362p ps=2.03u w=0.32u l=0.28u
X1765 a_3933_10377# WL[9] WBLB[3] VSS nfet_03v3 ad=0.139p pd=1.215u as=0.2362p ps=2.03u w=0.32u l=0.28u
X1766 RBL[136] a_2067_19145# VSS VSS nfet_03v3 ad=0.1516p pd=1.64u as=0.1516p ps=1.64u w=0.22u l=0.28u
X1767 RBL[230] a_5799_31201# VSS VSS nfet_03v3 ad=0.1516p pd=1.64u as=0.1516p ps=1.64u w=0.22u l=0.28u
X1768 RBL[207] a_6421_27913# VSS VSS nfet_03v3 ad=0.1516p pd=1.64u as=0.1516p ps=1.64u w=0.22u l=0.28u
X1769 RBL[199] a_6421_26817# VSS VSS nfet_03v3 ad=0.1516p pd=1.64u as=0.1516p ps=1.64u w=0.22u l=0.28u
X1770 VDD a_3342_24035# a_3311_23529# VDD pfet_03v3 ad=0.1496p pd=1.12u as=0.1936p ps=1.76u w=0.44u l=0.28u
X1771 VDD a_3342_22939# a_3311_22433# VDD pfet_03v3 ad=0.1496p pd=1.12u as=0.1936p ps=1.76u w=0.44u l=0.28u
X1772 RBL[140] a_4555_19145# VSS VSS nfet_03v3 ad=0.1516p pd=1.64u as=0.1516p ps=1.64u w=0.22u l=0.28u
X1773 RBL[117] a_5177_15857# VSS VSS nfet_03v3 ad=0.1516p pd=1.64u as=0.1516p ps=1.64u w=0.22u l=0.28u
X1774 RBL[125] a_5177_16953# VSS VSS nfet_03v3 ad=0.1516p pd=1.64u as=0.1516p ps=1.64u w=0.22u l=0.28u
X1775 VSS a_2098_20747# a_2067_20241# VSS nfet_03v3 ad=0.1108p pd=1.1u as=0.139p ps=1.215u w=0.22u l=0.28u
X1776 a_5830_33899# WL[30] WBL[6] VSS nfet_03v3 ad=0.1397p pd=1.22u as=0.1706p ps=1.7u w=0.32u l=0.28u
X1777 a_5830_32803# WL[29] WBL[6] VSS nfet_03v3 ad=0.1397p pd=1.22u as=0.1706p ps=1.7u w=0.32u l=0.28u
X1778 VDD a_5830_24035# a_5799_23529# VDD pfet_03v3 ad=0.1496p pd=1.12u as=0.1936p ps=1.76u w=0.44u l=0.28u
X1779 VDD a_5830_22939# a_5799_22433# VDD pfet_03v3 ad=0.1496p pd=1.12u as=0.1936p ps=1.76u w=0.44u l=0.28u
X1780 a_5208_28419# a_5177_27913# VSS VSS nfet_03v3 ad=0.1397p pd=1.22u as=0.1108p ps=1.1u w=0.22u l=0.28u
X1781 a_5208_27323# a_5177_26817# VSS VSS nfet_03v3 ad=0.1397p pd=1.22u as=0.1108p ps=1.1u w=0.22u l=0.28u
X1782 a_6452_1019# a_6421_513# VSS VSS nfet_03v3 ad=0.1397p pd=1.22u as=0.1108p ps=1.1u w=0.22u l=0.28u
X1783 a_6452_13075# a_6421_12569# VSS VSS nfet_03v3 ad=0.1397p pd=1.22u as=0.1108p ps=1.1u w=0.22u l=0.28u
X1784 a_6452_14171# a_6421_13665# VSS VSS nfet_03v3 ad=0.1397p pd=1.22u as=0.1108p ps=1.1u w=0.22u l=0.28u
X1785 VDD a_6452_20747# a_6421_20241# VDD pfet_03v3 ad=0.1496p pd=1.12u as=0.1936p ps=1.76u w=0.44u l=0.28u
X1786 VDD a_2098_3211# a_2067_2705# VDD pfet_03v3 ad=0.1496p pd=1.12u as=0.1936p ps=1.76u w=0.44u l=0.28u
X1787 a_3964_26227# WL[23] WBL[3] VSS nfet_03v3 ad=0.1397p pd=1.22u as=0.1706p ps=1.7u w=0.32u l=0.28u
X1788 a_3964_25131# WL[22] WBL[3] VSS nfet_03v3 ad=0.1397p pd=1.22u as=0.1706p ps=1.7u w=0.32u l=0.28u
X1789 a_3964_7595# a_3933_7089# VSS VSS nfet_03v3 ad=0.1397p pd=1.22u as=0.1108p ps=1.1u w=0.22u l=0.28u
X1790 a_5208_9787# a_5177_9281# VSS VSS nfet_03v3 ad=0.1397p pd=1.22u as=0.1108p ps=1.1u w=0.22u l=0.28u
X1791 a_6421_1609# WL[1] WBLB[7] VSS nfet_03v3 ad=0.139p pd=1.215u as=0.2362p ps=2.03u w=0.32u l=0.28u
X1792 a_3964_7595# WL[6] WBL[3] VSS nfet_03v3 ad=0.1397p pd=1.22u as=0.1706p ps=1.7u w=0.32u l=0.28u
X1793 a_3342_27323# a_3311_26817# VDD VDD pfet_03v3 ad=0.1936p pd=1.76u as=0.1496p ps=1.12u w=0.44u l=0.28u
X1794 a_3342_18555# a_3311_18049# VSS VSS nfet_03v3 ad=0.1397p pd=1.22u as=0.1108p ps=1.1u w=0.22u l=0.28u
X1795 a_3342_19651# a_3311_19145# VSS VSS nfet_03v3 ad=0.1397p pd=1.22u as=0.1108p ps=1.1u w=0.22u l=0.28u
X1796 a_4586_28419# WL[25] WBL[4] VSS nfet_03v3 ad=0.1397p pd=1.22u as=0.1706p ps=1.7u w=0.32u l=0.28u
X1797 a_4586_27323# WL[24] WBL[4] VSS nfet_03v3 ad=0.1397p pd=1.22u as=0.1706p ps=1.7u w=0.32u l=0.28u
X1798 VSS a_4586_33899# a_4555_33393# VSS nfet_03v3 ad=0.1108p pd=1.1u as=0.139p ps=1.215u w=0.22u l=0.28u
X1799 VSS a_4586_32803# a_4555_32297# VSS nfet_03v3 ad=0.1108p pd=1.1u as=0.139p ps=1.215u w=0.22u l=0.28u
X1800 a_2067_30105# WL[27] WBLB[0] VSS nfet_03v3 ad=0.139p pd=1.215u as=0.2362p ps=2.03u w=0.32u l=0.28u
X1801 RBL[54] a_5799_7089# VSS VSS nfet_03v3 ad=0.1516p pd=1.64u as=0.1516p ps=1.64u w=0.22u l=0.28u
X1802 RBL[255] a_6421_34489# a_6665_35171# VSS nfet_03v3 ad=0.1516p pd=1.64u as=0.1516p ps=1.64u w=0.22u l=0.28u
X1803 VSS a_2720_26227# a_2689_25721# VSS nfet_03v3 ad=0.1108p pd=1.1u as=0.139p ps=1.215u w=0.22u l=0.28u
X1804 VDD a_2720_34995# a_2689_34489# VDD pfet_03v3 ad=0.1496p pd=1.12u as=0.1936p ps=1.76u w=0.44u l=0.28u
X1805 VDD a_2720_33899# a_2689_33393# VDD pfet_03v3 ad=0.1496p pd=1.12u as=0.1936p ps=1.76u w=0.44u l=0.28u
X1806 RBL[7] a_6421_513# VSS VSS nfet_03v3 ad=0.1516p pd=1.64u as=0.1516p ps=1.64u w=0.22u l=0.28u
X1807 VDD a_3342_31707# a_3311_31201# VDD pfet_03v3 ad=0.1496p pd=1.12u as=0.1936p ps=1.76u w=0.44u l=0.28u
X1808 VDD a_3342_30611# a_3311_30105# VDD pfet_03v3 ad=0.1496p pd=1.12u as=0.1936p ps=1.76u w=0.44u l=0.28u
X1809 VSS a_3342_21843# a_3311_21337# VSS nfet_03v3 ad=0.1108p pd=1.1u as=0.139p ps=1.215u w=0.22u l=0.28u
X1810 VSS a_3342_22939# a_3311_22433# VSS nfet_03v3 ad=0.1108p pd=1.1u as=0.139p ps=1.215u w=0.22u l=0.28u
X1811 a_5177_27913# WL[25] WBLB[5] VSS nfet_03v3 ad=0.139p pd=1.215u as=0.2362p ps=2.03u w=0.32u l=0.28u
X1812 a_5177_26817# WL[24] WBLB[5] VSS nfet_03v3 ad=0.139p pd=1.215u as=0.2362p ps=2.03u w=0.32u l=0.28u
X1813 a_4586_14171# a_4555_13665# VDD VDD pfet_03v3 ad=0.1936p pd=1.76u as=0.1496p ps=1.12u w=0.44u l=0.28u
X1814 a_6421_19145# WL[17] WBLB[7] VSS nfet_03v3 ad=0.139p pd=1.215u as=0.2362p ps=2.03u w=0.32u l=0.28u
X1815 a_3964_25131# a_3933_24625# VDD VDD pfet_03v3 ad=0.1936p pd=1.76u as=0.1496p ps=1.12u w=0.44u l=0.28u
X1816 VSS a_5830_22939# a_5799_22433# VSS nfet_03v3 ad=0.1108p pd=1.1u as=0.139p ps=1.215u w=0.22u l=0.28u
X1817 VDD a_5830_31707# a_5799_31201# VDD pfet_03v3 ad=0.1496p pd=1.12u as=0.1936p ps=1.76u w=0.44u l=0.28u
X1818 VDD a_5830_30611# a_5799_30105# VDD pfet_03v3 ad=0.1496p pd=1.12u as=0.1936p ps=1.76u w=0.44u l=0.28u
X1819 VSS a_5830_21843# a_5799_21337# VSS nfet_03v3 ad=0.1108p pd=1.1u as=0.139p ps=1.215u w=0.22u l=0.28u
X1820 RBL[234] a_3311_32297# A[29] VDD pfet_03v3 ad=0.2082p pd=1.84u as=0.2024p ps=1.8u w=0.44u l=0.28u
X1821 RBL[226] a_3311_31201# A[28] VDD pfet_03v3 ad=0.2082p pd=1.84u as=0.2024p ps=1.8u w=0.44u l=0.28u
X1822 a_2720_14171# WL[12] WBL[1] VSS nfet_03v3 ad=0.1397p pd=1.22u as=0.1706p ps=1.7u w=0.32u l=0.28u
X1823 a_2720_15267# WL[13] WBL[1] VSS nfet_03v3 ad=0.1397p pd=1.22u as=0.1706p ps=1.7u w=0.32u l=0.28u
X1824 RBL[153] a_2720_21843# A[19] VSS nfet_03v3 ad=0.1516p pd=1.64u as=0.1516p ps=1.64u w=0.22u l=0.28u
X1825 RBL[161] a_2720_22939# A[20] VSS nfet_03v3 ad=0.1516p pd=1.64u as=0.1516p ps=1.64u w=0.22u l=0.28u
X1826 RBL[60] a_4555_8185# VSS VSS nfet_03v3 ad=0.1516p pd=1.64u as=0.1516p ps=1.64u w=0.22u l=0.28u
X1827 RBL[68] a_4555_9281# VSS VSS nfet_03v3 ad=0.1516p pd=1.64u as=0.1516p ps=1.64u w=0.22u l=0.28u
X1828 RBL[73] a_2689_10377# A[9] VDD pfet_03v3 ad=0.2082p pd=1.84u as=0.2024p ps=1.8u w=0.44u l=0.28u
X1829 RBL[140] a_4586_19651# A[17] VSS nfet_03v3 ad=0.1516p pd=1.64u as=0.1516p ps=1.64u w=0.22u l=0.28u
X1830 RBL[152] a_2067_21337# A[19] VDD pfet_03v3 ad=0.2082p pd=1.84u as=0.2024p ps=1.8u w=0.44u l=0.28u
X1831 RBL[117] a_5208_16363# A[14] VSS nfet_03v3 ad=0.1516p pd=1.64u as=0.1516p ps=1.64u w=0.22u l=0.28u
X1832 RBL[125] a_5208_17459# A[15] VSS nfet_03v3 ad=0.1516p pd=1.64u as=0.1516p ps=1.64u w=0.22u l=0.28u
X1833 RBL[144] a_2067_20241# A[18] VDD pfet_03v3 ad=0.2082p pd=1.84u as=0.2024p ps=1.8u w=0.44u l=0.28u
X1834 a_5799_29009# WL[26] WBLB[6] VSS nfet_03v3 ad=0.139p pd=1.215u as=0.2362p ps=2.03u w=0.32u l=0.28u
X1835 a_5830_10883# WL[9] WBL[6] VSS nfet_03v3 ad=0.1397p pd=1.22u as=0.1706p ps=1.7u w=0.32u l=0.28u
X1836 a_5830_11979# WL[10] WBL[6] VSS nfet_03v3 ad=0.1397p pd=1.22u as=0.1706p ps=1.7u w=0.32u l=0.28u
X1837 RBL[7] a_6452_1019# A[0] VSS nfet_03v3 ad=0.1516p pd=1.64u as=0.1516p ps=1.64u w=0.22u l=0.28u
X1838 a_3342_9787# a_3311_9281# VSS VSS nfet_03v3 ad=0.1397p pd=1.22u as=0.1108p ps=1.1u w=0.22u l=0.28u
X1839 a_5208_14171# a_5177_13665# VDD VDD pfet_03v3 ad=0.1936p pd=1.76u as=0.1496p ps=1.12u w=0.44u l=0.28u
X1840 RBL[227] a_3933_31201# VSS VSS nfet_03v3 ad=0.1516p pd=1.64u as=0.1516p ps=1.64u w=0.22u l=0.28u
X1841 a_3342_1019# a_3311_513# VSS VSS nfet_03v3 ad=0.1397p pd=1.22u as=0.1108p ps=1.1u w=0.22u l=0.28u
X1842 RBL[114] a_3311_15857# VSS VSS nfet_03v3 ad=0.1516p pd=1.64u as=0.1516p ps=1.64u w=0.22u l=0.28u
X1843 RBL[122] a_3311_16953# VSS VSS nfet_03v3 ad=0.1516p pd=1.64u as=0.1516p ps=1.64u w=0.22u l=0.28u
X1844 RBL[201] a_2689_27913# VSS VSS nfet_03v3 ad=0.1516p pd=1.64u as=0.1516p ps=1.64u w=0.22u l=0.28u
X1845 RBL[193] a_2689_26817# VSS VSS nfet_03v3 ad=0.1516p pd=1.64u as=0.1516p ps=1.64u w=0.22u l=0.28u
X1846 a_3342_28419# a_3311_27913# VSS VSS nfet_03v3 ad=0.1397p pd=1.22u as=0.1108p ps=1.1u w=0.22u l=0.28u
X1847 a_3342_27323# a_3311_26817# VSS VSS nfet_03v3 ad=0.1397p pd=1.22u as=0.1108p ps=1.1u w=0.22u l=0.28u
X1848 RBL[51] a_3933_7089# VSS VSS nfet_03v3 ad=0.1516p pd=1.64u as=0.1516p ps=1.64u w=0.22u l=0.28u
X1849 VDD a_4586_20747# a_4555_20241# VDD pfet_03v3 ad=0.1496p pd=1.12u as=0.1936p ps=1.76u w=0.44u l=0.28u
X1850 a_3964_25131# a_3933_24625# VSS VSS nfet_03v3 ad=0.1397p pd=1.22u as=0.1108p ps=1.1u w=0.22u l=0.28u
X1851 a_3964_24035# a_3933_23529# VSS VSS nfet_03v3 ad=0.1397p pd=1.22u as=0.1108p ps=1.1u w=0.22u l=0.28u
X1852 a_4586_13075# a_4555_12569# VSS VSS nfet_03v3 ad=0.1397p pd=1.22u as=0.1108p ps=1.1u w=0.22u l=0.28u
X1853 a_4586_14171# a_4555_13665# VSS VSS nfet_03v3 ad=0.1397p pd=1.22u as=0.1108p ps=1.1u w=0.22u l=0.28u
X1854 a_3964_32803# a_3933_32297# VDD VDD pfet_03v3 ad=0.1936p pd=1.76u as=0.1496p ps=1.12u w=0.44u l=0.28u
X1855 RBL[95] a_6421_12569# VSS VSS nfet_03v3 ad=0.1516p pd=1.64u as=0.1516p ps=1.64u w=0.22u l=0.28u
X1856 RBL[174] a_5799_23529# VSS VSS nfet_03v3 ad=0.1516p pd=1.64u as=0.1516p ps=1.64u w=0.22u l=0.28u
X1857 VDD a_2720_11979# a_2689_11473# VDD pfet_03v3 ad=0.1496p pd=1.12u as=0.1936p ps=1.76u w=0.44u l=0.28u
X1858 VDD a_2720_13075# a_2689_12569# VDD pfet_03v3 ad=0.1496p pd=1.12u as=0.1936p ps=1.76u w=0.44u l=0.28u
X1859 a_6452_17459# WL[15] WBL[7] VSS nfet_03v3 ad=0.1397p pd=1.22u as=0.1706p ps=1.7u w=0.32u l=0.28u
X1860 a_2720_22939# WL[20] WBL[1] VSS nfet_03v3 ad=0.1397p pd=1.22u as=0.1706p ps=1.7u w=0.32u l=0.28u
X1861 a_2098_26227# a_2067_25721# VDD VDD pfet_03v3 ad=0.1936p pd=1.76u as=0.1496p ps=1.12u w=0.44u l=0.28u
X1862 a_6452_16363# WL[14] WBL[7] VSS nfet_03v3 ad=0.1397p pd=1.22u as=0.1706p ps=1.7u w=0.32u l=0.28u
X1863 a_2098_16363# a_2067_15857# VSS VSS nfet_03v3 ad=0.1397p pd=1.22u as=0.1108p ps=1.1u w=0.22u l=0.28u
X1864 a_2098_17459# a_2067_16953# VSS VSS nfet_03v3 ad=0.1397p pd=1.22u as=0.1108p ps=1.1u w=0.22u l=0.28u
X1865 a_5830_34995# a_5799_34489# VSS VSS nfet_03v3 ad=0.1397p pd=1.22u as=0.1108p ps=1.1u w=0.22u l=0.28u
X1866 RBL[177] a_2689_24625# A[22] VDD pfet_03v3 ad=0.2082p pd=1.84u as=0.2024p ps=1.8u w=0.44u l=0.28u
X1867 VDD a_3964_4307# a_3933_3801# VDD pfet_03v3 ad=0.1496p pd=1.12u as=0.1936p ps=1.76u w=0.44u l=0.28u
X1868 RBL[1] a_2689_513# A[0] VDD pfet_03v3 ad=0.2082p pd=1.84u as=0.2024p ps=1.8u w=0.44u l=0.28u
X1869 a_5208_13075# a_5177_12569# VSS VSS nfet_03v3 ad=0.1397p pd=1.22u as=0.1108p ps=1.1u w=0.22u l=0.28u
X1870 a_5208_14171# a_5177_13665# VSS VSS nfet_03v3 ad=0.1397p pd=1.22u as=0.1108p ps=1.1u w=0.22u l=0.28u
X1871 a_6452_15267# a_6421_14761# VDD VDD pfet_03v3 ad=0.1936p pd=1.76u as=0.1496p ps=1.12u w=0.44u l=0.28u
X1872 RBL[237] a_5177_32297# VSS VSS nfet_03v3 ad=0.1516p pd=1.64u as=0.1516p ps=1.64u w=0.22u l=0.28u
X1873 RBL[4] a_4586_1019# A[0] VSS nfet_03v3 ad=0.1516p pd=1.64u as=0.1516p ps=1.64u w=0.22u l=0.28u
X1874 RBL[217] a_2720_30611# A[27] VSS nfet_03v3 ad=0.1516p pd=1.64u as=0.1516p ps=1.64u w=0.22u l=0.28u
X1875 VDD a_2720_5403# a_2689_4897# VDD pfet_03v3 ad=0.1496p pd=1.12u as=0.1936p ps=1.76u w=0.44u l=0.28u
X1876 a_5208_34995# WL[31] WBL[5] VSS nfet_03v3 ad=0.1397p pd=1.22u as=0.1706p ps=1.7u w=0.32u l=0.28u
X1877 RBL[134] a_5799_18049# A[16] VDD pfet_03v3 ad=0.2082p pd=1.84u as=0.2024p ps=1.8u w=0.44u l=0.28u
X1878 RBL[142] a_5799_19145# A[17] VDD pfet_03v3 ad=0.2082p pd=1.84u as=0.2024p ps=1.8u w=0.44u l=0.28u
X1879 RBL[249] a_2689_34489# a_2933_35171# VSS nfet_03v3 ad=0.1516p pd=1.64u as=0.1516p ps=1.64u w=0.22u l=0.28u
X1880 a_3342_28419# WL[25] WBL[2] VSS nfet_03v3 ad=0.1397p pd=1.22u as=0.1706p ps=1.7u w=0.32u l=0.28u
X1881 a_3342_27323# WL[24] WBL[2] VSS nfet_03v3 ad=0.1397p pd=1.22u as=0.1706p ps=1.7u w=0.32u l=0.28u
X1882 VDD a_6452_6499# a_6421_5993# VDD pfet_03v3 ad=0.1496p pd=1.12u as=0.1936p ps=1.76u w=0.44u l=0.28u
X1883 VDD a_6452_7595# a_6421_7089# VDD pfet_03v3 ad=0.1496p pd=1.12u as=0.1936p ps=1.76u w=0.44u l=0.28u
X1884 RBL[54] a_5799_7089# A[6] VDD pfet_03v3 ad=0.2082p pd=1.84u as=0.2024p ps=1.8u w=0.44u l=0.28u
X1885 RBL[62] a_5799_8185# A[7] VDD pfet_03v3 ad=0.2082p pd=1.84u as=0.2024p ps=1.8u w=0.44u l=0.28u
X1886 VSS a_3964_30611# a_3933_30105# VSS nfet_03v3 ad=0.1108p pd=1.1u as=0.139p ps=1.215u w=0.22u l=0.28u
X1887 a_4586_19651# WL[17] WBL[4] VSS nfet_03v3 ad=0.1397p pd=1.22u as=0.1706p ps=1.7u w=0.32u l=0.28u
X1888 a_2720_4307# a_2689_3801# VDD VDD pfet_03v3 ad=0.1936p pd=1.76u as=0.1496p ps=1.12u w=0.44u l=0.28u
X1889 VSS a_2720_10883# a_2689_10377# VSS nfet_03v3 ad=0.1108p pd=1.1u as=0.139p ps=1.215u w=0.22u l=0.28u
X1890 VSS a_2720_11979# a_2689_11473# VSS nfet_03v3 ad=0.1108p pd=1.1u as=0.139p ps=1.215u w=0.22u l=0.28u
X1891 a_6452_24035# WL[21] WBL[7] VSS nfet_03v3 ad=0.1397p pd=1.22u as=0.1706p ps=1.7u w=0.32u l=0.28u
X1892 a_2720_29515# a_2689_29009# VDD VDD pfet_03v3 ad=0.1936p pd=1.76u as=0.1496p ps=1.12u w=0.44u l=0.28u
X1893 a_6452_5403# a_6421_4897# VDD VDD pfet_03v3 ad=0.1936p pd=1.76u as=0.1496p ps=1.12u w=0.44u l=0.28u
X1894 a_2720_28419# a_2689_27913# VDD VDD pfet_03v3 ad=0.1936p pd=1.76u as=0.1496p ps=1.12u w=0.44u l=0.28u
X1895 a_3342_14171# a_3311_13665# VDD VDD pfet_03v3 ad=0.1936p pd=1.76u as=0.1496p ps=1.12u w=0.44u l=0.28u
X1896 a_5177_19145# WL[17] WBLB[5] VSS nfet_03v3 ad=0.139p pd=1.215u as=0.2362p ps=2.03u w=0.32u l=0.28u
X1897 a_3964_10883# a_3933_10377# VDD VDD pfet_03v3 ad=0.1936p pd=1.76u as=0.1496p ps=1.12u w=0.44u l=0.28u
X1898 VDD a_2098_4307# a_2067_3801# VDD pfet_03v3 ad=0.1496p pd=1.12u as=0.1936p ps=1.76u w=0.44u l=0.28u
X1899 a_5177_1609# WL[1] WBLB[5] VSS nfet_03v3 ad=0.139p pd=1.215u as=0.2362p ps=2.03u w=0.32u l=0.28u
X1900 a_5830_21843# a_5799_21337# VDD VDD pfet_03v3 ad=0.1936p pd=1.76u as=0.1496p ps=1.12u w=0.44u l=0.28u
X1901 a_4555_29009# WL[26] WBLB[4] VSS nfet_03v3 ad=0.139p pd=1.215u as=0.2362p ps=2.03u w=0.32u l=0.28u
X1902 a_4586_1019# WL[0] WBL[4] VSS nfet_03v3 ad=0.1397p pd=1.22u as=0.1706p ps=1.7u w=0.32u l=0.28u
X1903 RBL[48] a_2067_7089# VSS VSS nfet_03v3 ad=0.1516p pd=1.64u as=0.1516p ps=1.64u w=0.22u l=0.28u
X1904 RBL[48] a_2098_7595# A[6] VSS nfet_03v3 ad=0.1516p pd=1.64u as=0.1516p ps=1.64u w=0.22u l=0.28u
X1905 VSS a_3964_4307# a_3933_3801# VSS nfet_03v3 ad=0.1108p pd=1.1u as=0.139p ps=1.215u w=0.22u l=0.28u
X1906 RBL[241] a_2689_33393# A[30] VDD pfet_03v3 ad=0.2082p pd=1.84u as=0.2024p ps=1.8u w=0.44u l=0.28u
X1907 RBL[237] a_5208_32803# A[29] VSS nfet_03v3 ad=0.1516p pd=1.64u as=0.1516p ps=1.64u w=0.22u l=0.28u
X1908 a_2098_16363# WL[14] WBL[0] VSS nfet_03v3 ad=0.1397p pd=1.22u as=0.1706p ps=1.7u w=0.32u l=0.28u
X1909 a_2098_17459# WL[15] WBL[0] VSS nfet_03v3 ad=0.1397p pd=1.22u as=0.1706p ps=1.7u w=0.32u l=0.28u
X1910 a_6452_24035# a_6421_23529# VDD VDD pfet_03v3 ad=0.1936p pd=1.76u as=0.1496p ps=1.12u w=0.44u l=0.28u
X1911 a_6452_22939# a_6421_22433# VDD VDD pfet_03v3 ad=0.1936p pd=1.76u as=0.1496p ps=1.12u w=0.44u l=0.28u
X1912 a_3311_8185# WL[7] WBLB[2] VSS nfet_03v3 ad=0.139p pd=1.215u as=0.2362p ps=2.03u w=0.32u l=0.28u
X1913 a_3311_9281# WL[8] WBLB[2] VSS nfet_03v3 ad=0.139p pd=1.215u as=0.2362p ps=2.03u w=0.32u l=0.28u
X1914 RBL[171] a_3933_23529# VSS VSS nfet_03v3 ad=0.1516p pd=1.64u as=0.1516p ps=1.64u w=0.22u l=0.28u
X1915 a_3964_3211# a_3933_2705# VSS VSS nfet_03v3 ad=0.1397p pd=1.22u as=0.1108p ps=1.1u w=0.22u l=0.28u
X1916 a_3964_2115# a_3933_1609# VSS VSS nfet_03v3 ad=0.1397p pd=1.22u as=0.1108p ps=1.1u w=0.22u l=0.28u
X1917 a_5208_13075# WL[11] WBL[5] VSS nfet_03v3 ad=0.1397p pd=1.22u as=0.1706p ps=1.7u w=0.32u l=0.28u
X1918 VDD a_4586_6499# a_4555_5993# VDD pfet_03v3 ad=0.1496p pd=1.12u as=0.1936p ps=1.76u w=0.44u l=0.28u
X1919 VDD a_4586_7595# a_4555_7089# VDD pfet_03v3 ad=0.1496p pd=1.12u as=0.1936p ps=1.76u w=0.44u l=0.28u
X1920 RBL[89] a_2689_12569# VSS VSS nfet_03v3 ad=0.1516p pd=1.64u as=0.1516p ps=1.64u w=0.22u l=0.28u
X1921 RBL[215] a_6452_29515# A[26] VSS nfet_03v3 ad=0.1516p pd=1.64u as=0.1516p ps=1.64u w=0.22u l=0.28u
X1922 VSS a_2720_5403# a_2689_4897# VSS nfet_03v3 ad=0.1108p pd=1.1u as=0.139p ps=1.215u w=0.22u l=0.28u
X1923 a_3342_13075# a_3311_12569# VSS VSS nfet_03v3 ad=0.1397p pd=1.22u as=0.1108p ps=1.1u w=0.22u l=0.28u
X1924 a_3342_14171# a_3311_13665# VSS VSS nfet_03v3 ad=0.1397p pd=1.22u as=0.1108p ps=1.1u w=0.22u l=0.28u
X1925 RBL[1] a_2720_1019# A[0] VSS nfet_03v3 ad=0.1516p pd=1.64u as=0.1516p ps=1.64u w=0.22u l=0.28u
X1926 a_5208_2115# WL[1] WBL[5] VSS nfet_03v3 ad=0.1397p pd=1.22u as=0.1706p ps=1.7u w=0.32u l=0.28u
X1927 VDD a_5208_29515# a_5177_29009# VDD pfet_03v3 ad=0.1496p pd=1.12u as=0.1936p ps=1.76u w=0.44u l=0.28u
X1928 VDD a_5208_28419# a_5177_27913# VDD pfet_03v3 ad=0.1496p pd=1.12u as=0.1936p ps=1.76u w=0.44u l=0.28u
X1929 a_4586_15267# a_4555_14761# VDD VDD pfet_03v3 ad=0.1936p pd=1.76u as=0.1496p ps=1.12u w=0.44u l=0.28u
X1930 RBL[234] a_3311_32297# VSS VSS nfet_03v3 ad=0.1516p pd=1.64u as=0.1516p ps=1.64u w=0.22u l=0.28u
X1931 a_4586_5403# a_4555_4897# VDD VDD pfet_03v3 ad=0.1936p pd=1.76u as=0.1496p ps=1.12u w=0.44u l=0.28u
X1932 a_2720_4307# a_2689_3801# VSS VSS nfet_03v3 ad=0.1397p pd=1.22u as=0.1108p ps=1.1u w=0.22u l=0.28u
X1933 a_2098_17459# a_2067_16953# VDD VDD pfet_03v3 ad=0.1936p pd=1.76u as=0.1496p ps=1.12u w=0.44u l=0.28u
X1934 a_2098_18555# a_2067_18049# VDD VDD pfet_03v3 ad=0.1936p pd=1.76u as=0.1496p ps=1.12u w=0.44u l=0.28u
X1935 a_5830_20747# a_5799_20241# VSS VSS nfet_03v3 ad=0.1397p pd=1.22u as=0.1108p ps=1.1u w=0.22u l=0.28u
X1936 a_3311_18049# WL[16] WBLB[2] VSS nfet_03v3 ad=0.139p pd=1.215u as=0.2362p ps=2.03u w=0.32u l=0.28u
X1937 RBL[208] a_2067_29009# VSS VSS nfet_03v3 ad=0.1516p pd=1.64u as=0.1516p ps=1.64u w=0.22u l=0.28u
X1938 a_3933_20241# WL[18] WBLB[3] VSS nfet_03v3 ad=0.139p pd=1.215u as=0.2362p ps=2.03u w=0.32u l=0.28u
X1939 a_6452_5403# a_6421_4897# VSS VSS nfet_03v3 ad=0.1397p pd=1.22u as=0.1108p ps=1.1u w=0.22u l=0.28u
X1940 VSS a_3964_1019# a_3933_513# VSS nfet_03v3 ad=0.1108p pd=1.1u as=0.139p ps=1.215u w=0.22u l=0.28u
X1941 a_5208_15267# a_5177_14761# VDD VDD pfet_03v3 ad=0.1936p pd=1.76u as=0.1496p ps=1.12u w=0.44u l=0.28u
X1942 RBL[212] a_4555_29009# VSS VSS nfet_03v3 ad=0.1516p pd=1.64u as=0.1516p ps=1.64u w=0.22u l=0.28u
X1943 a_6421_13665# WL[12] WBLB[7] VSS nfet_03v3 ad=0.139p pd=1.215u as=0.2362p ps=2.03u w=0.32u l=0.28u
X1944 a_6421_14761# WL[13] WBLB[7] VSS nfet_03v3 ad=0.139p pd=1.215u as=0.2362p ps=2.03u w=0.32u l=0.28u
X1945 RBL[189] a_5177_25721# VSS VSS nfet_03v3 ad=0.1516p pd=1.64u as=0.1516p ps=1.64u w=0.22u l=0.28u
X1946 RBL[181] a_5177_24625# VSS VSS nfet_03v3 ad=0.1516p pd=1.64u as=0.1516p ps=1.64u w=0.22u l=0.28u
X1947 a_2098_24035# WL[21] WBL[0] VSS nfet_03v3 ad=0.1397p pd=1.22u as=0.1706p ps=1.7u w=0.32u l=0.28u
X1948 VSS a_2098_30611# a_2067_30105# VSS nfet_03v3 ad=0.1108p pd=1.1u as=0.139p ps=1.215u w=0.22u l=0.28u
X1949 a_6452_31707# a_6421_31201# VDD VDD pfet_03v3 ad=0.1936p pd=1.76u as=0.1496p ps=1.12u w=0.44u l=0.28u
X1950 a_6452_30611# a_6421_30105# VDD VDD pfet_03v3 ad=0.1936p pd=1.76u as=0.1496p ps=1.12u w=0.44u l=0.28u
X1951 VSS a_2098_4307# a_2067_3801# VSS nfet_03v3 ad=0.1108p pd=1.1u as=0.139p ps=1.215u w=0.22u l=0.28u
X1952 a_6452_21843# a_6421_21337# VSS VSS nfet_03v3 ad=0.1397p pd=1.22u as=0.1108p ps=1.1u w=0.22u l=0.28u
X1953 a_6452_22939# a_6421_22433# VSS VSS nfet_03v3 ad=0.1397p pd=1.22u as=0.1108p ps=1.1u w=0.22u l=0.28u
X1954 a_3964_34995# WL[31] WBL[3] VSS nfet_03v3 ad=0.1397p pd=1.22u as=0.1706p ps=1.7u w=0.32u l=0.28u
X1955 a_5830_9787# WL[8] WBL[6] VSS nfet_03v3 ad=0.1397p pd=1.22u as=0.1706p ps=1.7u w=0.32u l=0.28u
X1956 a_5830_8691# WL[7] WBL[6] VSS nfet_03v3 ad=0.1397p pd=1.22u as=0.1706p ps=1.7u w=0.32u l=0.28u
X1957 a_3342_19651# WL[17] WBL[2] VSS nfet_03v3 ad=0.1397p pd=1.22u as=0.1706p ps=1.7u w=0.32u l=0.28u
X1958 RBL[112] a_2098_16363# A[14] VSS nfet_03v3 ad=0.1516p pd=1.64u as=0.1516p ps=1.64u w=0.22u l=0.28u
X1959 RBL[120] a_2098_17459# A[15] VSS nfet_03v3 ad=0.1516p pd=1.64u as=0.1516p ps=1.64u w=0.22u l=0.28u
X1960 a_2689_29009# WL[26] WBLB[1] VSS nfet_03v3 ad=0.139p pd=1.215u as=0.2362p ps=2.03u w=0.32u l=0.28u
X1961 a_3311_25721# WL[23] WBLB[2] VSS nfet_03v3 ad=0.139p pd=1.215u as=0.2362p ps=2.03u w=0.32u l=0.28u
X1962 a_3311_24625# WL[22] WBLB[2] VSS nfet_03v3 ad=0.139p pd=1.215u as=0.2362p ps=2.03u w=0.32u l=0.28u
X1963 a_3964_1019# a_3933_513# VSS VSS nfet_03v3 ad=0.1397p pd=1.22u as=0.1108p ps=1.1u w=0.22u l=0.28u
X1964 VSS a_2720_34995# a_2689_34489# VSS nfet_03v3 ad=0.1108p pd=1.1u as=0.139p ps=1.215u w=0.22u l=0.28u
X1965 VSS a_3342_31707# a_3311_31201# VSS nfet_03v3 ad=0.1108p pd=1.1u as=0.139p ps=1.215u w=0.22u l=0.28u
X1966 RBL[30] a_5830_4307# A[3] VSS nfet_03v3 ad=0.1516p pd=1.64u as=0.1516p ps=1.64u w=0.22u l=0.28u
X1967 a_6421_22433# WL[20] WBLB[7] VSS nfet_03v3 ad=0.139p pd=1.215u as=0.2362p ps=2.03u w=0.32u l=0.28u
X1968 RBL[245] a_5177_33393# VSS VSS nfet_03v3 ad=0.1516p pd=1.64u as=0.1516p ps=1.64u w=0.22u l=0.28u
X1969 a_4586_24035# a_4555_23529# VDD VDD pfet_03v3 ad=0.1936p pd=1.76u as=0.1496p ps=1.12u w=0.44u l=0.28u
X1970 a_4586_5403# a_4555_4897# VSS VSS nfet_03v3 ad=0.1397p pd=1.22u as=0.1108p ps=1.1u w=0.22u l=0.28u
X1971 a_4586_22939# a_4555_22433# VDD VDD pfet_03v3 ad=0.1936p pd=1.76u as=0.1496p ps=1.12u w=0.44u l=0.28u
X1972 VSS a_5830_31707# a_5799_31201# VSS nfet_03v3 ad=0.1108p pd=1.1u as=0.139p ps=1.215u w=0.22u l=0.28u
X1973 RBL[48] a_2067_7089# A[6] VDD pfet_03v3 ad=0.2082p pd=1.84u as=0.2024p ps=1.8u w=0.44u l=0.28u
X1974 RBL[56] a_2067_8185# A[7] VDD pfet_03v3 ad=0.2082p pd=1.84u as=0.2024p ps=1.8u w=0.44u l=0.28u
X1975 RBL[212] a_4586_29515# A[26] VSS nfet_03v3 ad=0.1516p pd=1.64u as=0.1516p ps=1.64u w=0.22u l=0.28u
X1976 RBL[216] a_2067_30105# A[27] VDD pfet_03v3 ad=0.2082p pd=1.84u as=0.2024p ps=1.8u w=0.44u l=0.28u
X1977 RBL[189] a_5208_26227# A[23] VSS nfet_03v3 ad=0.1516p pd=1.64u as=0.1516p ps=1.64u w=0.22u l=0.28u
X1978 RBL[181] a_5208_25131# A[22] VSS nfet_03v3 ad=0.1516p pd=1.64u as=0.1516p ps=1.64u w=0.22u l=0.28u
X1979 a_5830_20747# WL[18] WBL[6] VSS nfet_03v3 ad=0.1397p pd=1.22u as=0.1706p ps=1.7u w=0.32u l=0.28u
X1980 a_5208_24035# a_5177_23529# VDD VDD pfet_03v3 ad=0.1936p pd=1.76u as=0.1496p ps=1.12u w=0.44u l=0.28u
X1981 a_5208_22939# a_5177_22433# VDD VDD pfet_03v3 ad=0.1936p pd=1.76u as=0.1496p ps=1.12u w=0.44u l=0.28u
X1982 a_3933_30105# WL[27] WBLB[3] VSS nfet_03v3 ad=0.139p pd=1.215u as=0.2362p ps=2.03u w=0.32u l=0.28u
X1983 a_3964_13075# WL[11] WBL[3] VSS nfet_03v3 ad=0.1397p pd=1.22u as=0.1706p ps=1.7u w=0.32u l=0.28u
X1984 RBL[130] a_3342_18555# A[16] VSS nfet_03v3 ad=0.1516p pd=1.64u as=0.1516p ps=1.64u w=0.22u l=0.28u
X1985 a_5208_5403# a_5177_4897# VDD VDD pfet_03v3 ad=0.1936p pd=1.76u as=0.1496p ps=1.12u w=0.44u l=0.28u
X1986 RBL[103] a_6452_14171# A[12] VSS nfet_03v3 ad=0.1516p pd=1.64u as=0.1516p ps=1.64u w=0.22u l=0.28u
X1987 RBL[111] a_6452_15267# A[13] VSS nfet_03v3 ad=0.1516p pd=1.64u as=0.1516p ps=1.64u w=0.22u l=0.28u
X1988 a_3342_15267# a_3311_14761# VDD VDD pfet_03v3 ad=0.1936p pd=1.76u as=0.1496p ps=1.12u w=0.44u l=0.28u
X1989 RBL[94] a_5799_12569# A[11] VDD pfet_03v3 ad=0.2082p pd=1.84u as=0.2024p ps=1.8u w=0.44u l=0.28u
X1990 RBL[186] a_3311_25721# VSS VSS nfet_03v3 ad=0.1516p pd=1.64u as=0.1516p ps=1.64u w=0.22u l=0.28u
X1991 RBL[178] a_3311_24625# VSS VSS nfet_03v3 ad=0.1516p pd=1.64u as=0.1516p ps=1.64u w=0.22u l=0.28u
X1992 VDD a_6452_2115# a_6421_1609# VDD pfet_03v3 ad=0.1496p pd=1.12u as=0.1936p ps=1.76u w=0.44u l=0.28u
X1993 a_4586_14171# WL[12] WBL[4] VSS nfet_03v3 ad=0.1397p pd=1.22u as=0.1706p ps=1.7u w=0.32u l=0.28u
X1994 a_4586_15267# WL[13] WBL[4] VSS nfet_03v3 ad=0.1397p pd=1.22u as=0.1706p ps=1.7u w=0.32u l=0.28u
X1995 a_2067_18049# WL[16] WBLB[0] VSS nfet_03v3 ad=0.139p pd=1.215u as=0.2362p ps=2.03u w=0.32u l=0.28u
X1996 a_4586_21843# a_4555_21337# VSS VSS nfet_03v3 ad=0.1397p pd=1.22u as=0.1108p ps=1.1u w=0.22u l=0.28u
X1997 a_4586_22939# a_4555_22433# VSS VSS nfet_03v3 ad=0.1397p pd=1.22u as=0.1108p ps=1.1u w=0.22u l=0.28u
X1998 a_3964_33899# a_3933_33393# VSS VSS nfet_03v3 ad=0.1397p pd=1.22u as=0.1108p ps=1.1u w=0.22u l=0.28u
X1999 a_3964_32803# a_3933_32297# VSS VSS nfet_03v3 ad=0.1397p pd=1.22u as=0.1108p ps=1.1u w=0.22u l=0.28u
X2000 a_4586_31707# a_4555_31201# VDD VDD pfet_03v3 ad=0.1936p pd=1.76u as=0.1496p ps=1.12u w=0.44u l=0.28u
X2001 a_4586_30611# a_4555_30105# VDD VDD pfet_03v3 ad=0.1936p pd=1.76u as=0.1496p ps=1.12u w=0.44u l=0.28u
X2002 RBL[27] a_3964_4307# A[3] VSS nfet_03v3 ad=0.1516p pd=1.64u as=0.1516p ps=1.64u w=0.22u l=0.28u
X2003 RBL[96] a_2067_13665# VSS VSS nfet_03v3 ad=0.1516p pd=1.64u as=0.1516p ps=1.64u w=0.22u l=0.28u
X2004 RBL[104] a_2067_14761# VSS VSS nfet_03v3 ad=0.1516p pd=1.64u as=0.1516p ps=1.64u w=0.22u l=0.28u
X2005 a_2720_31707# WL[28] WBL[1] VSS nfet_03v3 ad=0.1397p pd=1.22u as=0.1706p ps=1.7u w=0.32u l=0.28u
X2006 VDD a_2720_21843# a_2689_21337# VDD pfet_03v3 ad=0.1496p pd=1.12u as=0.1936p ps=1.76u w=0.44u l=0.28u
X2007 RBL[159] a_6421_21337# VSS VSS nfet_03v3 ad=0.1516p pd=1.64u as=0.1516p ps=1.64u w=0.22u l=0.28u
X2008 RBL[167] a_6421_22433# VSS VSS nfet_03v3 ad=0.1516p pd=1.64u as=0.1516p ps=1.64u w=0.22u l=0.28u
X2009 a_2098_26227# a_2067_25721# VSS VSS nfet_03v3 ad=0.1397p pd=1.22u as=0.1108p ps=1.1u w=0.22u l=0.28u
X2010 a_2720_15267# a_2689_14761# VSS VSS nfet_03v3 ad=0.1397p pd=1.22u as=0.1108p ps=1.1u w=0.22u l=0.28u
X2011 a_2098_34995# a_2067_34489# VDD VDD pfet_03v3 ad=0.1936p pd=1.76u as=0.1496p ps=1.12u w=0.44u l=0.28u
X2012 a_2098_33899# a_2067_33393# VDD VDD pfet_03v3 ad=0.1936p pd=1.76u as=0.1496p ps=1.12u w=0.44u l=0.28u
X2013 a_3933_5993# WL[5] WBLB[3] VSS nfet_03v3 ad=0.139p pd=1.215u as=0.2362p ps=2.03u w=0.32u l=0.28u
X2014 a_3933_4897# WL[4] WBLB[3] VSS nfet_03v3 ad=0.139p pd=1.215u as=0.2362p ps=2.03u w=0.32u l=0.28u
X2015 a_5177_14761# WL[13] WBLB[5] VSS nfet_03v3 ad=0.139p pd=1.215u as=0.2362p ps=2.03u w=0.32u l=0.28u
X2016 a_5177_13665# WL[12] WBLB[5] VSS nfet_03v3 ad=0.139p pd=1.215u as=0.2362p ps=2.03u w=0.32u l=0.28u
X2017 RBL[108] a_4555_14761# VSS VSS nfet_03v3 ad=0.1516p pd=1.64u as=0.1516p ps=1.64u w=0.22u l=0.28u
X2018 RBL[100] a_4555_13665# VSS VSS nfet_03v3 ad=0.1516p pd=1.64u as=0.1516p ps=1.64u w=0.22u l=0.28u
X2019 RBL[13] a_5177_1609# VSS VSS nfet_03v3 ad=0.1516p pd=1.64u as=0.1516p ps=1.64u w=0.22u l=0.28u
X2020 RBL[77] a_5177_10377# VSS VSS nfet_03v3 ad=0.1516p pd=1.64u as=0.1516p ps=1.64u w=0.22u l=0.28u
X2021 RBL[85] a_5177_11473# VSS VSS nfet_03v3 ad=0.1516p pd=1.64u as=0.1516p ps=1.64u w=0.22u l=0.28u
X2022 RBL[245] a_5208_33899# A[30] VSS nfet_03v3 ad=0.1516p pd=1.64u as=0.1516p ps=1.64u w=0.22u l=0.28u
X2023 a_2067_8185# WL[7] WBLB[0] VSS nfet_03v3 ad=0.139p pd=1.215u as=0.2362p ps=2.03u w=0.32u l=0.28u
X2024 a_2067_9281# WL[8] WBLB[0] VSS nfet_03v3 ad=0.139p pd=1.215u as=0.2362p ps=2.03u w=0.32u l=0.28u
X2025 a_5208_31707# a_5177_31201# VDD VDD pfet_03v3 ad=0.1936p pd=1.76u as=0.1496p ps=1.12u w=0.44u l=0.28u
X2026 a_5208_30611# a_5177_30105# VDD VDD pfet_03v3 ad=0.1936p pd=1.76u as=0.1496p ps=1.12u w=0.44u l=0.28u
X2027 RBL[67] a_3933_9281# A[8] VDD pfet_03v3 ad=0.2082p pd=1.84u as=0.2024p ps=1.8u w=0.44u l=0.28u
X2028 a_5208_21843# a_5177_21337# VSS VSS nfet_03v3 ad=0.1397p pd=1.22u as=0.1108p ps=1.1u w=0.22u l=0.28u
X2029 a_5208_22939# a_5177_22433# VSS VSS nfet_03v3 ad=0.1397p pd=1.22u as=0.1108p ps=1.1u w=0.22u l=0.28u
X2030 a_5799_15857# WL[14] WBLB[6] VSS nfet_03v3 ad=0.139p pd=1.215u as=0.2362p ps=2.03u w=0.32u l=0.28u
X2031 a_5799_16953# WL[15] WBLB[6] VSS nfet_03v3 ad=0.139p pd=1.215u as=0.2362p ps=2.03u w=0.32u l=0.28u
X2032 a_3964_2115# WL[1] WBL[3] VSS nfet_03v3 ad=0.1397p pd=1.22u as=0.1706p ps=1.7u w=0.32u l=0.28u
X2033 RBL[123] a_3933_16953# A[15] VDD pfet_03v3 ad=0.2082p pd=1.84u as=0.2024p ps=1.8u w=0.44u l=0.28u
X2034 a_3342_5403# a_3311_4897# VDD VDD pfet_03v3 ad=0.1936p pd=1.76u as=0.1496p ps=1.12u w=0.44u l=0.28u
X2035 VSS a_2720_6499# a_2689_5993# VSS nfet_03v3 ad=0.1108p pd=1.1u as=0.139p ps=1.215u w=0.22u l=0.28u
X2036 RBL[242] a_3311_33393# VSS VSS nfet_03v3 ad=0.1516p pd=1.64u as=0.1516p ps=1.64u w=0.22u l=0.28u
X2037 RBL[206] a_5799_27913# A[25] VDD pfet_03v3 ad=0.2082p pd=1.84u as=0.2024p ps=1.8u w=0.44u l=0.28u
X2038 VSS a_6452_7595# a_6421_7089# VSS nfet_03v3 ad=0.1108p pd=1.1u as=0.139p ps=1.215u w=0.22u l=0.28u
X2039 a_4586_22939# WL[20] WBL[4] VSS nfet_03v3 ad=0.1397p pd=1.22u as=0.1706p ps=1.7u w=0.32u l=0.28u
X2040 a_3311_3801# WL[3] WBLB[2] VSS nfet_03v3 ad=0.139p pd=1.215u as=0.2362p ps=2.03u w=0.32u l=0.28u
X2041 a_3311_2705# WL[2] WBLB[2] VSS nfet_03v3 ad=0.139p pd=1.215u as=0.2362p ps=2.03u w=0.32u l=0.28u
X2042 a_2067_25721# WL[23] WBLB[0] VSS nfet_03v3 ad=0.139p pd=1.215u as=0.2362p ps=2.03u w=0.32u l=0.28u
X2043 a_2067_24625# WL[22] WBLB[0] VSS nfet_03v3 ad=0.139p pd=1.215u as=0.2362p ps=2.03u w=0.32u l=0.28u
X2044 a_5208_5403# a_5177_4897# VSS VSS nfet_03v3 ad=0.1397p pd=1.22u as=0.1108p ps=1.1u w=0.22u l=0.28u
X2045 a_5830_30611# WL[27] WBL[6] VSS nfet_03v3 ad=0.1397p pd=1.22u as=0.1706p ps=1.7u w=0.32u l=0.28u
X2046 VDD a_4586_2115# a_4555_1609# VDD pfet_03v3 ad=0.1496p pd=1.12u as=0.1936p ps=1.76u w=0.44u l=0.28u
X2047 a_5208_1019# a_5177_513# VDD VDD pfet_03v3 ad=0.1936p pd=1.76u as=0.1496p ps=1.12u w=0.44u l=0.28u
X2048 VSS a_2720_20747# a_2689_20241# VSS nfet_03v3 ad=0.1108p pd=1.1u as=0.139p ps=1.215u w=0.22u l=0.28u
X2049 a_6452_33899# WL[30] WBL[7] VSS nfet_03v3 ad=0.1397p pd=1.22u as=0.1706p ps=1.7u w=0.32u l=0.28u
X2050 RBL[232] a_2098_32803# A[29] VSS nfet_03v3 ad=0.1516p pd=1.64u as=0.1516p ps=1.64u w=0.22u l=0.28u
X2051 a_6452_32803# WL[29] WBL[7] VSS nfet_03v3 ad=0.1397p pd=1.22u as=0.1706p ps=1.7u w=0.32u l=0.28u
X2052 a_2720_29515# a_2689_29009# VSS VSS nfet_03v3 ad=0.1397p pd=1.22u as=0.1108p ps=1.1u w=0.22u l=0.28u
X2053 a_6452_6499# a_6421_5993# VSS VSS nfet_03v3 ad=0.1397p pd=1.22u as=0.1108p ps=1.1u w=0.22u l=0.28u
X2054 VSS a_4586_1019# a_4555_513# VSS nfet_03v3 ad=0.1108p pd=1.1u as=0.139p ps=1.215u w=0.22u l=0.28u
X2055 a_2098_8691# WL[7] WBL[0] VSS nfet_03v3 ad=0.1397p pd=1.22u as=0.1706p ps=1.7u w=0.32u l=0.28u
X2056 a_2098_9787# WL[8] WBL[0] VSS nfet_03v3 ad=0.1397p pd=1.22u as=0.1706p ps=1.7u w=0.32u l=0.28u
X2057 a_5177_22433# WL[20] WBLB[5] VSS nfet_03v3 ad=0.139p pd=1.215u as=0.2362p ps=2.03u w=0.32u l=0.28u
X2058 a_3342_24035# a_3311_23529# VDD VDD pfet_03v3 ad=0.1936p pd=1.76u as=0.1496p ps=1.12u w=0.44u l=0.28u
X2059 VSS a_5208_15267# a_5177_14761# VSS nfet_03v3 ad=0.1108p pd=1.1u as=0.139p ps=1.215u w=0.22u l=0.28u
X2060 a_3342_22939# a_3311_22433# VDD VDD pfet_03v3 ad=0.1936p pd=1.76u as=0.1496p ps=1.12u w=0.44u l=0.28u
X2061 RBL[215] a_6421_29009# A[26] VDD pfet_03v3 ad=0.2082p pd=1.84u as=0.2024p ps=1.8u w=0.44u l=0.28u
X2062 a_6452_6499# WL[5] WBL[7] VSS nfet_03v3 ad=0.1397p pd=1.22u as=0.1706p ps=1.7u w=0.32u l=0.28u
X2063 a_6452_5403# WL[4] WBL[7] VSS nfet_03v3 ad=0.1397p pd=1.22u as=0.1706p ps=1.7u w=0.32u l=0.28u
X2064 a_3964_20747# a_3933_20241# VDD VDD pfet_03v3 ad=0.1936p pd=1.76u as=0.1496p ps=1.12u w=0.44u l=0.28u
X2065 RBL[57] a_2689_8185# VSS VSS nfet_03v3 ad=0.1516p pd=1.64u as=0.1516p ps=1.64u w=0.22u l=0.28u
X2066 RBL[65] a_2689_9281# VSS VSS nfet_03v3 ad=0.1516p pd=1.64u as=0.1516p ps=1.64u w=0.22u l=0.28u
X2067 a_2098_11979# a_2067_11473# VDD VDD pfet_03v3 ad=0.1936p pd=1.76u as=0.1496p ps=1.12u w=0.44u l=0.28u
X2068 a_2098_13075# a_2067_12569# VDD VDD pfet_03v3 ad=0.1936p pd=1.76u as=0.1496p ps=1.12u w=0.44u l=0.28u
X2069 RBL[28] a_4555_3801# VSS VSS nfet_03v3 ad=0.1516p pd=1.64u as=0.1516p ps=1.64u w=0.22u l=0.28u
X2070 RBL[10] a_3311_1609# VSS VSS nfet_03v3 ad=0.1516p pd=1.64u as=0.1516p ps=1.64u w=0.22u l=0.28u
X2071 VDD a_3964_19651# a_3933_19145# VDD pfet_03v3 ad=0.1496p pd=1.12u as=0.1936p ps=1.76u w=0.44u l=0.28u
X2072 a_5799_7089# WL[6] WBLB[6] VSS nfet_03v3 ad=0.139p pd=1.215u as=0.2362p ps=2.03u w=0.32u l=0.28u
X2073 RBL[100] a_4586_14171# A[12] VSS nfet_03v3 ad=0.1516p pd=1.64u as=0.1516p ps=1.64u w=0.22u l=0.28u
X2074 RBL[108] a_4586_15267# A[13] VSS nfet_03v3 ad=0.1516p pd=1.64u as=0.1516p ps=1.64u w=0.22u l=0.28u
X2075 RBL[223] a_6421_30105# VSS VSS nfet_03v3 ad=0.1516p pd=1.64u as=0.1516p ps=1.64u w=0.22u l=0.28u
X2076 RBL[77] a_5208_10883# A[9] VSS nfet_03v3 ad=0.1516p pd=1.64u as=0.1516p ps=1.64u w=0.22u l=0.28u
X2077 RBL[85] a_5208_11979# A[10] VSS nfet_03v3 ad=0.1516p pd=1.64u as=0.1516p ps=1.64u w=0.22u l=0.28u
X2078 a_5799_23529# WL[21] WBLB[6] VSS nfet_03v3 ad=0.139p pd=1.215u as=0.2362p ps=2.03u w=0.32u l=0.28u
X2079 RBL[149] a_5177_20241# VSS VSS nfet_03v3 ad=0.1516p pd=1.64u as=0.1516p ps=1.64u w=0.22u l=0.28u
X2080 VDD a_5208_8691# a_5177_8185# VDD pfet_03v3 ad=0.1496p pd=1.12u as=0.1936p ps=1.76u w=0.44u l=0.28u
X2081 VDD a_5208_9787# a_5177_9281# VDD pfet_03v3 ad=0.1496p pd=1.12u as=0.1936p ps=1.76u w=0.44u l=0.28u
X2082 a_5830_4307# WL[3] WBL[6] VSS nfet_03v3 ad=0.1397p pd=1.22u as=0.1706p ps=1.7u w=0.32u l=0.28u
X2083 a_5830_3211# WL[2] WBL[6] VSS nfet_03v3 ad=0.1397p pd=1.22u as=0.1706p ps=1.7u w=0.32u l=0.28u
X2084 RBL[10] a_3342_2115# A[1] VSS nfet_03v3 ad=0.1516p pd=1.64u as=0.1516p ps=1.64u w=0.22u l=0.28u
X2085 a_5208_21843# WL[19] WBL[5] VSS nfet_03v3 ad=0.1397p pd=1.22u as=0.1706p ps=1.7u w=0.32u l=0.28u
X2086 a_4586_1019# a_4555_513# VSS VSS nfet_03v3 ad=0.1397p pd=1.22u as=0.1108p ps=1.1u w=0.22u l=0.28u
X2087 VSS a_4586_7595# a_4555_7089# VSS nfet_03v3 ad=0.1108p pd=1.1u as=0.139p ps=1.215u w=0.22u l=0.28u
X2088 VSS a_5830_9787# a_5799_9281# VSS nfet_03v3 ad=0.1108p pd=1.1u as=0.139p ps=1.215u w=0.22u l=0.28u
X2089 VDD a_6452_26227# a_6421_25721# VDD pfet_03v3 ad=0.1496p pd=1.12u as=0.1936p ps=1.76u w=0.44u l=0.28u
X2090 VSS a_6452_16363# a_6421_15857# VSS nfet_03v3 ad=0.1108p pd=1.1u as=0.139p ps=1.215u w=0.22u l=0.28u
X2091 VSS a_6452_17459# a_6421_16953# VSS nfet_03v3 ad=0.1108p pd=1.1u as=0.139p ps=1.215u w=0.22u l=0.28u
X2092 RBL[82] a_3311_11473# VSS VSS nfet_03v3 ad=0.1516p pd=1.64u as=0.1516p ps=1.64u w=0.22u l=0.28u
X2093 RBL[74] a_3311_10377# VSS VSS nfet_03v3 ad=0.1516p pd=1.64u as=0.1516p ps=1.64u w=0.22u l=0.28u
X2094 RBL[137] a_2720_19651# A[17] VSS nfet_03v3 ad=0.1516p pd=1.64u as=0.1516p ps=1.64u w=0.22u l=0.28u
X2095 RBL[153] a_2689_21337# VSS VSS nfet_03v3 ad=0.1516p pd=1.64u as=0.1516p ps=1.64u w=0.22u l=0.28u
X2096 RBL[161] a_2689_22433# VSS VSS nfet_03v3 ad=0.1516p pd=1.64u as=0.1516p ps=1.64u w=0.22u l=0.28u
X2097 RBL[231] a_6452_31707# A[28] VSS nfet_03v3 ad=0.1516p pd=1.64u as=0.1516p ps=1.64u w=0.22u l=0.28u
X2098 a_3342_5403# a_3311_4897# VSS VSS nfet_03v3 ad=0.1397p pd=1.22u as=0.1108p ps=1.1u w=0.22u l=0.28u
X2099 a_3342_14171# WL[12] WBL[2] VSS nfet_03v3 ad=0.1397p pd=1.22u as=0.1706p ps=1.7u w=0.32u l=0.28u
X2100 a_3342_15267# WL[13] WBL[2] VSS nfet_03v3 ad=0.1397p pd=1.22u as=0.1706p ps=1.7u w=0.32u l=0.28u
X2101 a_3342_21843# a_3311_21337# VSS VSS nfet_03v3 ad=0.1397p pd=1.22u as=0.1108p ps=1.1u w=0.22u l=0.28u
X2102 a_3342_22939# a_3311_22433# VSS VSS nfet_03v3 ad=0.1397p pd=1.22u as=0.1108p ps=1.1u w=0.22u l=0.28u
X2103 a_3342_31707# a_3311_31201# VDD VDD pfet_03v3 ad=0.1936p pd=1.76u as=0.1496p ps=1.12u w=0.44u l=0.28u
X2104 a_3342_30611# a_3311_30105# VDD VDD pfet_03v3 ad=0.1936p pd=1.76u as=0.1496p ps=1.12u w=0.44u l=0.28u
X2105 VSS a_5208_29515# a_5177_29009# VSS nfet_03v3 ad=0.1108p pd=1.1u as=0.139p ps=1.215u w=0.22u l=0.28u
X2106 a_4586_6499# a_4555_5993# VSS VSS nfet_03v3 ad=0.1397p pd=1.22u as=0.1108p ps=1.1u w=0.22u l=0.28u
X2107 a_2098_1019# WL[0] WBL[0] VSS nfet_03v3 ad=0.1397p pd=1.22u as=0.1706p ps=1.7u w=0.32u l=0.28u
X2108 RBL[118] a_5830_16363# A[14] VSS nfet_03v3 ad=0.1516p pd=1.64u as=0.1516p ps=1.64u w=0.22u l=0.28u
X2109 RBL[126] a_5830_17459# A[15] VSS nfet_03v3 ad=0.1516p pd=1.64u as=0.1516p ps=1.64u w=0.22u l=0.28u
X2110 a_6452_10883# WL[9] WBL[7] VSS nfet_03v3 ad=0.1397p pd=1.22u as=0.1706p ps=1.7u w=0.32u l=0.28u
X2111 a_2098_10883# a_2067_10377# VSS VSS nfet_03v3 ad=0.1397p pd=1.22u as=0.1108p ps=1.1u w=0.22u l=0.28u
X2112 a_6452_11979# WL[10] WBL[7] VSS nfet_03v3 ad=0.1397p pd=1.22u as=0.1706p ps=1.7u w=0.32u l=0.28u
X2113 a_2098_11979# a_2067_11473# VSS VSS nfet_03v3 ad=0.1397p pd=1.22u as=0.1108p ps=1.1u w=0.22u l=0.28u
X2114 a_2720_16363# a_2689_15857# VDD VDD pfet_03v3 ad=0.1936p pd=1.76u as=0.1496p ps=1.12u w=0.44u l=0.28u
X2115 a_5830_30611# a_5799_30105# VSS VSS nfet_03v3 ad=0.1397p pd=1.22u as=0.1108p ps=1.1u w=0.22u l=0.28u
X2116 VDD a_3964_27323# a_3933_26817# VDD pfet_03v3 ad=0.1496p pd=1.12u as=0.1936p ps=1.76u w=0.44u l=0.28u
X2117 VSS a_3964_18555# a_3933_18049# VSS nfet_03v3 ad=0.1108p pd=1.1u as=0.139p ps=1.215u w=0.22u l=0.28u
X2118 VSS a_3964_19651# a_3933_19145# VSS nfet_03v3 ad=0.1108p pd=1.1u as=0.139p ps=1.215u w=0.22u l=0.28u
X2119 RBL[224] a_2067_31201# VSS VSS nfet_03v3 ad=0.1516p pd=1.64u as=0.1516p ps=1.64u w=0.22u l=0.28u
X2120 RBL[228] a_4555_31201# VSS VSS nfet_03v3 ad=0.1516p pd=1.64u as=0.1516p ps=1.64u w=0.22u l=0.28u
X2121 VDD a_5208_1019# a_5177_513# VDD pfet_03v3 ad=0.1496p pd=1.12u as=0.1936p ps=1.76u w=0.44u l=0.28u
X2122 VSS a_5208_8691# a_5177_8185# VSS nfet_03v3 ad=0.1108p pd=1.1u as=0.139p ps=1.215u w=0.22u l=0.28u
X2123 a_2098_33899# WL[30] WBL[0] VSS nfet_03v3 ad=0.1397p pd=1.22u as=0.1706p ps=1.7u w=0.32u l=0.28u
X2124 a_2098_32803# WL[29] WBL[0] VSS nfet_03v3 ad=0.1397p pd=1.22u as=0.1706p ps=1.7u w=0.32u l=0.28u
X2125 RBL[39] a_6421_4897# VSS VSS nfet_03v3 ad=0.1516p pd=1.64u as=0.1516p ps=1.64u w=0.22u l=0.28u
X2126 RBL[47] a_6421_5993# VSS VSS nfet_03v3 ad=0.1516p pd=1.64u as=0.1516p ps=1.64u w=0.22u l=0.28u
X2127 a_6452_31707# a_6421_31201# VSS VSS nfet_03v3 ad=0.1397p pd=1.22u as=0.1108p ps=1.1u w=0.22u l=0.28u
X2128 a_4555_15857# WL[14] WBLB[4] VSS nfet_03v3 ad=0.139p pd=1.215u as=0.2362p ps=2.03u w=0.32u l=0.28u
X2129 a_4555_16953# WL[15] WBLB[4] VSS nfet_03v3 ad=0.139p pd=1.215u as=0.2362p ps=2.03u w=0.32u l=0.28u
X2130 RBL[149] a_5208_20747# A[18] VSS nfet_03v3 ad=0.1516p pd=1.64u as=0.1516p ps=1.64u w=0.22u l=0.28u
X2131 RBL[212] a_4555_29009# A[26] VDD pfet_03v3 ad=0.2082p pd=1.84u as=0.2024p ps=1.8u w=0.44u l=0.28u
X2132 RBL[102] a_5799_13665# A[12] VDD pfet_03v3 ad=0.2082p pd=1.84u as=0.2024p ps=1.8u w=0.44u l=0.28u
X2133 a_3342_22939# WL[20] WBL[2] VSS nfet_03v3 ad=0.1397p pd=1.22u as=0.1706p ps=1.7u w=0.32u l=0.28u
X2134 RBL[22] a_5799_2705# A[2] VDD pfet_03v3 ad=0.2082p pd=1.84u as=0.2024p ps=1.8u w=0.44u l=0.28u
X2135 RBL[14] a_5799_1609# A[1] VDD pfet_03v3 ad=0.2082p pd=1.84u as=0.2024p ps=1.8u w=0.44u l=0.28u
X2136 VDD a_2098_19651# a_2067_19145# VDD pfet_03v3 ad=0.1496p pd=1.12u as=0.1936p ps=1.76u w=0.44u l=0.28u
X2137 RBL[39] a_6452_5403# A[4] VSS nfet_03v3 ad=0.1516p pd=1.64u as=0.1516p ps=1.64u w=0.22u l=0.28u
X2138 RBL[21] a_5208_3211# A[2] VSS nfet_03v3 ad=0.1516p pd=1.64u as=0.1516p ps=1.64u w=0.22u l=0.28u
X2139 RBL[47] a_6452_6499# A[5] VSS nfet_03v3 ad=0.1516p pd=1.64u as=0.1516p ps=1.64u w=0.22u l=0.28u
X2140 RBL[184] a_2098_26227# A[23] VSS nfet_03v3 ad=0.1516p pd=1.64u as=0.1516p ps=1.64u w=0.22u l=0.28u
X2141 VDD a_5830_1019# a_5799_513# VDD pfet_03v3 ad=0.1496p pd=1.12u as=0.1936p ps=1.76u w=0.44u l=0.28u
X2142 RBL[176] a_2098_25131# A[22] VSS nfet_03v3 ad=0.1516p pd=1.64u as=0.1516p ps=1.64u w=0.22u l=0.28u
X2143 a_3311_34489# WL[31] WBLB[2] VSS nfet_03v3 ad=0.139p pd=1.215u as=0.2362p ps=2.03u w=0.32u l=0.28u
X2144 RBL[213] a_5177_29009# A[26] VDD pfet_03v3 ad=0.2082p pd=1.84u as=0.2024p ps=1.8u w=0.44u l=0.28u
X2145 VDD a_3342_8691# a_3311_8185# VDD pfet_03v3 ad=0.1496p pd=1.12u as=0.1936p ps=1.76u w=0.44u l=0.28u
X2146 VDD a_3342_9787# a_3311_9281# VDD pfet_03v3 ad=0.1496p pd=1.12u as=0.1936p ps=1.76u w=0.44u l=0.28u
X2147 RBL[111] a_6421_14761# A[13] VDD pfet_03v3 ad=0.2082p pd=1.84u as=0.2024p ps=1.8u w=0.44u l=0.28u
X2148 VDD a_5208_16363# a_5177_15857# VDD pfet_03v3 ad=0.1496p pd=1.12u as=0.1936p ps=1.76u w=0.44u l=0.28u
X2149 RBL[119] a_6421_15857# A[14] VDD pfet_03v3 ad=0.2082p pd=1.84u as=0.2024p ps=1.8u w=0.44u l=0.28u
X2150 RBL[217] a_2689_30105# VSS VSS nfet_03v3 ad=0.1516p pd=1.64u as=0.1516p ps=1.64u w=0.22u l=0.28u
X2151 RBL[146] a_3311_20241# VSS VSS nfet_03v3 ad=0.1516p pd=1.64u as=0.1516p ps=1.64u w=0.22u l=0.28u
X2152 a_6421_31201# WL[28] WBLB[7] VSS nfet_03v3 ad=0.139p pd=1.215u as=0.2362p ps=2.03u w=0.32u l=0.28u
X2153 a_4555_23529# WL[21] WBLB[4] VSS nfet_03v3 ad=0.139p pd=1.215u as=0.2362p ps=2.03u w=0.32u l=0.28u
X2154 a_2720_25131# a_2689_24625# VDD VDD pfet_03v3 ad=0.1936p pd=1.76u as=0.1496p ps=1.12u w=0.44u l=0.28u
X2155 VSS a_4586_16363# a_4555_15857# VSS nfet_03v3 ad=0.1108p pd=1.1u as=0.139p ps=1.215u w=0.22u l=0.28u
X2156 VSS a_4586_17459# a_4555_16953# VSS nfet_03v3 ad=0.1108p pd=1.1u as=0.139p ps=1.215u w=0.22u l=0.28u
X2157 VSS a_3964_28419# a_3933_27913# VSS nfet_03v3 ad=0.1108p pd=1.1u as=0.139p ps=1.215u w=0.22u l=0.28u
X2158 VSS a_3964_27323# a_3933_26817# VSS nfet_03v3 ad=0.1108p pd=1.1u as=0.139p ps=1.215u w=0.22u l=0.28u
X2159 VDD a_4586_26227# a_4555_25721# VDD pfet_03v3 ad=0.1496p pd=1.12u as=0.1936p ps=1.76u w=0.44u l=0.28u
X2160 RBL[228] a_4586_31707# A[28] VSS nfet_03v3 ad=0.1516p pd=1.64u as=0.1516p ps=1.64u w=0.22u l=0.28u
X2161 a_5830_6499# a_5799_5993# VDD VDD pfet_03v3 ad=0.1936p pd=1.76u as=0.1496p ps=1.12u w=0.44u l=0.28u
X2162 a_5830_7595# a_5799_7089# VDD VDD pfet_03v3 ad=0.1936p pd=1.76u as=0.1496p ps=1.12u w=0.44u l=0.28u
X2163 a_2098_10883# WL[9] WBL[0] VSS nfet_03v3 ad=0.1397p pd=1.22u as=0.1706p ps=1.7u w=0.32u l=0.28u
X2164 a_2098_11979# WL[10] WBL[0] VSS nfet_03v3 ad=0.1397p pd=1.22u as=0.1706p ps=1.7u w=0.32u l=0.28u
X2165 a_2067_3801# WL[3] WBLB[0] VSS nfet_03v3 ad=0.139p pd=1.215u as=0.2362p ps=2.03u w=0.32u l=0.28u
X2166 a_2067_2705# WL[2] WBLB[0] VSS nfet_03v3 ad=0.139p pd=1.215u as=0.2362p ps=2.03u w=0.32u l=0.28u
X2167 RBL[115] a_3964_16363# A[14] VSS nfet_03v3 ad=0.1516p pd=1.64u as=0.1516p ps=1.64u w=0.22u l=0.28u
X2168 RBL[123] a_3964_17459# A[15] VSS nfet_03v3 ad=0.1516p pd=1.64u as=0.1516p ps=1.64u w=0.22u l=0.28u
X2169 RBL[202] a_3342_28419# A[25] VSS nfet_03v3 ad=0.1516p pd=1.64u as=0.1516p ps=1.64u w=0.22u l=0.28u
X2170 RBL[194] a_3342_27323# A[24] VSS nfet_03v3 ad=0.1516p pd=1.64u as=0.1516p ps=1.64u w=0.22u l=0.28u
X2171 a_5208_6499# a_5177_5993# VSS VSS nfet_03v3 ad=0.1397p pd=1.22u as=0.1108p ps=1.1u w=0.22u l=0.28u
X2172 a_3964_21843# WL[19] WBL[3] VSS nfet_03v3 ad=0.1397p pd=1.22u as=0.1706p ps=1.7u w=0.32u l=0.28u
X2173 VSS a_2098_18555# a_2067_18049# VSS nfet_03v3 ad=0.1108p pd=1.1u as=0.139p ps=1.215u w=0.22u l=0.28u
X2174 VSS a_2098_19651# a_2067_19145# VSS nfet_03v3 ad=0.1108p pd=1.1u as=0.139p ps=1.215u w=0.22u l=0.28u
X2175 VDD a_2098_27323# a_2067_26817# VDD pfet_03v3 ad=0.1496p pd=1.12u as=0.1936p ps=1.76u w=0.44u l=0.28u
X2176 RBL[240] a_2098_33899# A[30] VSS nfet_03v3 ad=0.1516p pd=1.64u as=0.1516p ps=1.64u w=0.22u l=0.28u
X2177 VDD a_6452_17459# a_6421_16953# VDD pfet_03v3 ad=0.1496p pd=1.12u as=0.1936p ps=1.76u w=0.44u l=0.28u
X2178 VDD a_6452_18555# a_6421_18049# VDD pfet_03v3 ad=0.1496p pd=1.12u as=0.1936p ps=1.76u w=0.44u l=0.28u
X2179 RBL[83] a_3933_11473# A[10] VDD pfet_03v3 ad=0.2082p pd=1.84u as=0.2024p ps=1.8u w=0.44u l=0.28u
X2180 RBL[175] a_6452_24035# A[21] VSS nfet_03v3 ad=0.1516p pd=1.64u as=0.1516p ps=1.64u w=0.22u l=0.28u
X2181 VSS a_3342_8691# a_3311_8185# VSS nfet_03v3 ad=0.1108p pd=1.1u as=0.139p ps=1.215u w=0.22u l=0.28u
X2182 RBL[36] a_4586_5403# A[4] VSS nfet_03v3 ad=0.1516p pd=1.64u as=0.1516p ps=1.64u w=0.22u l=0.28u
X2183 RBL[44] a_4586_6499# A[5] VSS nfet_03v3 ad=0.1516p pd=1.64u as=0.1516p ps=1.64u w=0.22u l=0.28u
X2184 VSS a_6452_3211# a_6421_2705# VSS nfet_03v3 ad=0.1108p pd=1.1u as=0.139p ps=1.215u w=0.22u l=0.28u
X2185 VSS a_6452_2115# a_6421_1609# VSS nfet_03v3 ad=0.1108p pd=1.1u as=0.139p ps=1.215u w=0.22u l=0.28u
X2186 RBL[166] a_5799_22433# A[20] VDD pfet_03v3 ad=0.2082p pd=1.84u as=0.2024p ps=1.8u w=0.44u l=0.28u
X2187 a_4555_7089# WL[6] WBLB[4] VSS nfet_03v3 ad=0.139p pd=1.215u as=0.2362p ps=2.03u w=0.32u l=0.28u
X2188 a_2689_15857# WL[14] WBLB[1] VSS nfet_03v3 ad=0.139p pd=1.215u as=0.2362p ps=2.03u w=0.32u l=0.28u
X2189 a_2689_16953# WL[15] WBLB[1] VSS nfet_03v3 ad=0.139p pd=1.215u as=0.2362p ps=2.03u w=0.32u l=0.28u
X2190 a_4586_31707# a_4555_31201# VSS VSS nfet_03v3 ad=0.1397p pd=1.22u as=0.1108p ps=1.1u w=0.22u l=0.28u
X2191 a_3311_12569# WL[11] WBLB[2] VSS nfet_03v3 ad=0.139p pd=1.215u as=0.2362p ps=2.03u w=0.32u l=0.28u
X2192 RBL[168] a_2067_23529# VSS VSS nfet_03v3 ad=0.1516p pd=1.64u as=0.1516p ps=1.64u w=0.22u l=0.28u
X2193 RBL[22] a_5799_2705# VSS VSS nfet_03v3 ad=0.1516p pd=1.64u as=0.1516p ps=1.64u w=0.22u l=0.28u
X2194 RBL[238] a_5830_32803# A[29] VSS nfet_03v3 ad=0.1516p pd=1.64u as=0.1516p ps=1.64u w=0.22u l=0.28u
X2195 a_2720_25131# a_2689_24625# VSS VSS nfet_03v3 ad=0.1397p pd=1.22u as=0.1108p ps=1.1u w=0.22u l=0.28u
X2196 a_2720_24035# a_2689_23529# VSS VSS nfet_03v3 ad=0.1397p pd=1.22u as=0.1108p ps=1.1u w=0.22u l=0.28u
X2197 a_2098_34995# a_2067_34489# VSS VSS nfet_03v3 ad=0.1397p pd=1.22u as=0.1108p ps=1.1u w=0.22u l=0.28u
X2198 a_2720_32803# a_2689_32297# VDD VDD pfet_03v3 ad=0.1936p pd=1.76u as=0.1496p ps=1.12u w=0.44u l=0.28u
X2199 a_2098_4307# WL[3] WBL[0] VSS nfet_03v3 ad=0.1397p pd=1.22u as=0.1706p ps=1.7u w=0.32u l=0.28u
X2200 a_2098_3211# WL[2] WBL[0] VSS nfet_03v3 ad=0.1397p pd=1.22u as=0.1706p ps=1.7u w=0.32u l=0.28u
X2201 a_2098_1019# a_2067_513# VSS VSS nfet_03v3 ad=0.1397p pd=1.22u as=0.1108p ps=1.1u w=0.22u l=0.28u
X2202 RBL[172] a_4555_23529# VSS VSS nfet_03v3 ad=0.1516p pd=1.64u as=0.1516p ps=1.64u w=0.22u l=0.28u
X2203 VDD a_5208_25131# a_5177_24625# VDD pfet_03v3 ad=0.1496p pd=1.12u as=0.1936p ps=1.76u w=0.44u l=0.28u
X2204 RBL[175] a_6421_23529# A[21] VDD pfet_03v3 ad=0.2082p pd=1.84u as=0.2024p ps=1.8u w=0.44u l=0.28u
X2205 a_5208_31707# a_5177_31201# VSS VSS nfet_03v3 ad=0.1397p pd=1.22u as=0.1108p ps=1.1u w=0.22u l=0.28u
X2206 VDD a_3342_29515# a_3311_29009# VDD pfet_03v3 ad=0.1496p pd=1.12u as=0.1936p ps=1.76u w=0.44u l=0.28u
X2207 VDD a_3342_28419# a_3311_27913# VDD pfet_03v3 ad=0.1496p pd=1.12u as=0.1936p ps=1.76u w=0.44u l=0.28u
X2208 RBL[250] a_3342_34995# A[31] VSS nfet_03v3 ad=0.1516p pd=1.64u as=0.1516p ps=1.64u w=0.22u l=0.28u
X2209 VDD a_3964_14171# a_3933_13665# VDD pfet_03v3 ad=0.1496p pd=1.12u as=0.1936p ps=1.76u w=0.44u l=0.28u
X2210 VDD a_5830_29515# a_5799_29009# VDD pfet_03v3 ad=0.1496p pd=1.12u as=0.1936p ps=1.76u w=0.44u l=0.28u
X2211 VDD a_5830_28419# a_5799_27913# VDD pfet_03v3 ad=0.1496p pd=1.12u as=0.1936p ps=1.76u w=0.44u l=0.28u
X2212 RBL[210] a_3311_29009# A[26] VDD pfet_03v3 ad=0.2082p pd=1.84u as=0.2024p ps=1.8u w=0.44u l=0.28u
X2213 RBL[108] a_4555_14761# A[13] VDD pfet_03v3 ad=0.2082p pd=1.84u as=0.2024p ps=1.8u w=0.44u l=0.28u
X2214 RBL[116] a_4555_15857# A[14] VDD pfet_03v3 ad=0.2082p pd=1.84u as=0.2024p ps=1.8u w=0.44u l=0.28u
X2215 RBL[195] a_3933_26817# A[24] VDD pfet_03v3 ad=0.2082p pd=1.84u as=0.2024p ps=1.8u w=0.44u l=0.28u
X2216 RBL[187] a_3933_25721# A[23] VDD pfet_03v3 ad=0.2082p pd=1.84u as=0.2024p ps=1.8u w=0.44u l=0.28u
X2217 a_3342_6499# a_3311_5993# VSS VSS nfet_03v3 ad=0.1397p pd=1.22u as=0.1108p ps=1.1u w=0.22u l=0.28u
X2218 a_4586_7595# WL[6] WBL[4] VSS nfet_03v3 ad=0.1397p pd=1.22u as=0.1706p ps=1.7u w=0.32u l=0.28u
X2219 VDD a_5208_3211# a_5177_2705# VDD pfet_03v3 ad=0.1496p pd=1.12u as=0.1936p ps=1.76u w=0.44u l=0.28u
X2220 a_3933_18049# WL[16] WBLB[3] VSS nfet_03v3 ad=0.139p pd=1.215u as=0.2362p ps=2.03u w=0.32u l=0.28u
X2221 RBL[128] a_2067_18049# A[16] VDD pfet_03v3 ad=0.2082p pd=1.84u as=0.2024p ps=1.8u w=0.44u l=0.28u
X2222 RBL[136] a_2067_19145# A[17] VDD pfet_03v3 ad=0.2082p pd=1.84u as=0.2024p ps=1.8u w=0.44u l=0.28u
X2223 a_4586_31707# WL[28] WBL[4] VSS nfet_03v3 ad=0.1397p pd=1.22u as=0.1706p ps=1.7u w=0.32u l=0.28u
X2224 RBL[72] a_2098_10883# A[9] VSS nfet_03v3 ad=0.1516p pd=1.64u as=0.1516p ps=1.64u w=0.22u l=0.28u
X2225 RBL[80] a_2098_11979# A[10] VSS nfet_03v3 ad=0.1516p pd=1.64u as=0.1516p ps=1.64u w=0.22u l=0.28u
X2226 a_2689_23529# WL[21] WBLB[1] VSS nfet_03v3 ad=0.139p pd=1.215u as=0.2362p ps=2.03u w=0.32u l=0.28u
X2227 a_2067_34489# WL[31] WBLB[0] VSS nfet_03v3 ad=0.139p pd=1.215u as=0.2362p ps=2.03u w=0.32u l=0.28u
X2228 VSS a_2098_28419# a_2067_27913# VSS nfet_03v3 ad=0.1108p pd=1.1u as=0.139p ps=1.215u w=0.22u l=0.28u
X2229 VSS a_2098_27323# a_2067_26817# VSS nfet_03v3 ad=0.1108p pd=1.1u as=0.139p ps=1.215u w=0.22u l=0.28u
X2230 VSS a_4586_3211# a_4555_2705# VSS nfet_03v3 ad=0.1108p pd=1.1u as=0.139p ps=1.215u w=0.22u l=0.28u
X2231 VSS a_4586_2115# a_4555_1609# VSS nfet_03v3 ad=0.1108p pd=1.1u as=0.139p ps=1.215u w=0.22u l=0.28u
X2232 RBL[109] a_5177_14761# A[13] VDD pfet_03v3 ad=0.2082p pd=1.84u as=0.2024p ps=1.8u w=0.44u l=0.28u
X2233 RBL[117] a_5177_15857# A[14] VDD pfet_03v3 ad=0.2082p pd=1.84u as=0.2024p ps=1.8u w=0.44u l=0.28u
X2234 VSS a_2720_30611# a_2689_30105# VSS nfet_03v3 ad=0.1108p pd=1.1u as=0.139p ps=1.215u w=0.22u l=0.28u
X2235 a_2689_7089# WL[6] WBLB[1] VSS nfet_03v3 ad=0.139p pd=1.215u as=0.2362p ps=2.03u w=0.32u l=0.28u
X2236 a_5177_31201# WL[28] WBLB[5] VSS nfet_03v3 ad=0.139p pd=1.215u as=0.2362p ps=2.03u w=0.32u l=0.28u
X2237 RBL[19] a_3933_2705# VSS VSS nfet_03v3 ad=0.1516p pd=1.64u as=0.1516p ps=1.64u w=0.22u l=0.28u
X2238 VDD a_5208_32803# a_5177_32297# VDD pfet_03v3 ad=0.1496p pd=1.12u as=0.1936p ps=1.76u w=0.44u l=0.28u
X2239 VSS a_5208_25131# a_5177_24625# VSS nfet_03v3 ad=0.1108p pd=1.1u as=0.139p ps=1.215u w=0.22u l=0.28u
X2240 VSS a_5208_24035# a_5177_23529# VSS nfet_03v3 ad=0.1108p pd=1.1u as=0.139p ps=1.215u w=0.22u l=0.28u
X2241 RBL[16] a_2067_2705# A[2] VDD pfet_03v3 ad=0.2082p pd=1.84u as=0.2024p ps=1.8u w=0.44u l=0.28u
X2242 RBL[8] a_2067_1609# A[1] VDD pfet_03v3 ad=0.2082p pd=1.84u as=0.2024p ps=1.8u w=0.44u l=0.28u
X2243 a_2720_10883# a_2689_10377# VDD VDD pfet_03v3 ad=0.1936p pd=1.76u as=0.1496p ps=1.12u w=0.44u l=0.28u
X2244 a_2098_21843# a_2067_21337# VDD VDD pfet_03v3 ad=0.1936p pd=1.76u as=0.1496p ps=1.12u w=0.44u l=0.28u
X2245 VSS a_3964_13075# a_3933_12569# VSS nfet_03v3 ad=0.1108p pd=1.1u as=0.139p ps=1.215u w=0.22u l=0.28u
X2246 VSS a_3964_14171# a_3933_13665# VSS nfet_03v3 ad=0.1108p pd=1.1u as=0.139p ps=1.215u w=0.22u l=0.28u
X2247 VDD a_4586_17459# a_4555_16953# VDD pfet_03v3 ad=0.1496p pd=1.12u as=0.1936p ps=1.76u w=0.44u l=0.28u
X2248 VDD a_4586_18555# a_4555_18049# VDD pfet_03v3 ad=0.1496p pd=1.12u as=0.1936p ps=1.76u w=0.44u l=0.28u
X2249 RBL[33] a_2720_5403# A[4] VSS nfet_03v3 ad=0.1516p pd=1.64u as=0.1516p ps=1.64u w=0.22u l=0.28u
X2250 RBL[41] a_2720_6499# A[5] VSS nfet_03v3 ad=0.1516p pd=1.64u as=0.1516p ps=1.64u w=0.22u l=0.28u
X2251 RBL[172] a_4586_24035# A[21] VSS nfet_03v3 ad=0.1516p pd=1.64u as=0.1516p ps=1.64u w=0.22u l=0.28u
X2252 a_5799_33393# WL[30] WBLB[6] VSS nfet_03v3 ad=0.139p pd=1.215u as=0.2362p ps=2.03u w=0.32u l=0.28u
X2253 a_5799_32297# WL[29] WBLB[6] VSS nfet_03v3 ad=0.139p pd=1.215u as=0.2362p ps=2.03u w=0.32u l=0.28u
X2254 RBL[90] a_3342_13075# A[11] VSS nfet_03v3 ad=0.1516p pd=1.64u as=0.1516p ps=1.64u w=0.22u l=0.28u
X2255 a_3933_25721# WL[23] WBLB[3] VSS nfet_03v3 ad=0.139p pd=1.215u as=0.2362p ps=2.03u w=0.32u l=0.28u
X2256 a_3933_24625# WL[22] WBLB[3] VSS nfet_03v3 ad=0.139p pd=1.215u as=0.2362p ps=2.03u w=0.32u l=0.28u
X2257 VSS a_2098_1019# a_2067_513# VSS nfet_03v3 ad=0.1108p pd=1.1u as=0.139p ps=1.215u w=0.22u l=0.28u
X2258 RBL[235] a_3964_32803# A[29] VSS nfet_03v3 ad=0.1516p pd=1.64u as=0.1516p ps=1.64u w=0.22u l=0.28u
X2259 VSS a_6452_26227# a_6421_25721# VSS nfet_03v3 ad=0.1108p pd=1.1u as=0.139p ps=1.215u w=0.22u l=0.28u
X2260 VDD a_6452_34995# a_6421_34489# VDD pfet_03v3 ad=0.1496p pd=1.12u as=0.1936p ps=1.76u w=0.44u l=0.28u
X2261 VDD a_6452_33899# a_6421_33393# VDD pfet_03v3 ad=0.1496p pd=1.12u as=0.1936p ps=1.76u w=0.44u l=0.28u
X2262 RBL[251] a_3933_34489# A[31] VDD pfet_03v3 ad=0.2082p pd=1.84u as=0.2024p ps=1.8u w=0.44u l=0.28u
X2263 RBL[209] a_2720_29515# A[26] VSS nfet_03v3 ad=0.1516p pd=1.64u as=0.1516p ps=1.64u w=0.22u l=0.28u
X2264 RBL[172] a_4555_23529# A[21] VDD pfet_03v3 ad=0.2082p pd=1.84u as=0.2024p ps=1.8u w=0.44u l=0.28u
X2265 a_2098_7595# a_2067_7089# VDD VDD pfet_03v3 ad=0.1936p pd=1.76u as=0.1496p ps=1.12u w=0.44u l=0.28u
X2266 a_2098_6499# a_2067_5993# VDD VDD pfet_03v3 ad=0.1936p pd=1.76u as=0.1496p ps=1.12u w=0.44u l=0.28u
X2267 a_3342_31707# a_3311_31201# VSS VSS nfet_03v3 ad=0.1397p pd=1.22u as=0.1108p ps=1.1u w=0.22u l=0.28u
X2268 a_2067_12569# WL[11] WBLB[0] VSS nfet_03v3 ad=0.139p pd=1.215u as=0.2362p ps=2.03u w=0.32u l=0.28u
X2269 VDD a_2098_14171# a_2067_13665# VDD pfet_03v3 ad=0.1496p pd=1.12u as=0.1936p ps=1.76u w=0.44u l=0.28u
X2270 RBL[190] a_5830_26227# A[23] VSS nfet_03v3 ad=0.1516p pd=1.64u as=0.1516p ps=1.64u w=0.22u l=0.28u
X2271 RBL[182] a_5830_25131# A[22] VSS nfet_03v3 ad=0.1516p pd=1.64u as=0.1516p ps=1.64u w=0.22u l=0.28u
X2272 a_5830_18555# WL[16] WBL[6] VSS nfet_03v3 ad=0.1397p pd=1.22u as=0.1706p ps=1.7u w=0.32u l=0.28u
X2273 a_6452_20747# WL[18] WBL[7] VSS nfet_03v3 ad=0.1397p pd=1.22u as=0.1706p ps=1.7u w=0.32u l=0.28u
X2274 RBL[144] a_2098_20747# A[18] VSS nfet_03v3 ad=0.1516p pd=1.64u as=0.1516p ps=1.64u w=0.22u l=0.28u
X2275 a_2098_20747# a_2067_20241# VSS VSS nfet_03v3 ad=0.1397p pd=1.22u as=0.1108p ps=1.1u w=0.22u l=0.28u
X2276 VDD a_6452_1019# a_6421_513# VDD pfet_03v3 ad=0.1496p pd=1.12u as=0.1936p ps=1.76u w=0.44u l=0.28u
X2277 VSS a_2720_1019# a_2689_513# VSS nfet_03v3 ad=0.1108p pd=1.1u as=0.139p ps=1.215u w=0.22u l=0.28u
X2278 RBL[173] a_5177_23529# A[21] VDD pfet_03v3 ad=0.2082p pd=1.84u as=0.2024p ps=1.8u w=0.44u l=0.28u
X2279 VDD a_3342_3211# a_3311_2705# VDD pfet_03v3 ad=0.1496p pd=1.12u as=0.1936p ps=1.76u w=0.44u l=0.28u
X2280 VDD a_5208_10883# a_5177_10377# VDD pfet_03v3 ad=0.1496p pd=1.12u as=0.1936p ps=1.76u w=0.44u l=0.28u
X2281 RBL[79] a_6421_10377# A[9] VDD pfet_03v3 ad=0.2082p pd=1.84u as=0.2024p ps=1.8u w=0.44u l=0.28u
X2282 RBL[35] a_3933_4897# A[4] VDD pfet_03v3 ad=0.2082p pd=1.84u as=0.2024p ps=1.8u w=0.44u l=0.28u
X2283 RBL[27] a_3933_3801# A[3] VDD pfet_03v3 ad=0.2082p pd=1.84u as=0.2024p ps=1.8u w=0.44u l=0.28u
X2284 RBL[106] a_3311_14761# A[13] VDD pfet_03v3 ad=0.2082p pd=1.84u as=0.2024p ps=1.8u w=0.44u l=0.28u
X2285 RBL[114] a_3311_15857# A[14] VDD pfet_03v3 ad=0.2082p pd=1.84u as=0.2024p ps=1.8u w=0.44u l=0.28u
X2286 a_5799_10377# WL[9] WBLB[6] VSS nfet_03v3 ad=0.139p pd=1.215u as=0.2362p ps=2.03u w=0.32u l=0.28u
X2287 a_5799_11473# WL[10] WBLB[6] VSS nfet_03v3 ad=0.139p pd=1.215u as=0.2362p ps=2.03u w=0.32u l=0.28u
X2288 RBL[16] a_2098_3211# A[2] VSS nfet_03v3 ad=0.1516p pd=1.64u as=0.1516p ps=1.64u w=0.22u l=0.28u
X2289 RBL[16] a_2067_2705# VSS VSS nfet_03v3 ad=0.1516p pd=1.64u as=0.1516p ps=1.64u w=0.22u l=0.28u
X2290 a_5830_19651# a_5799_19145# VDD VDD pfet_03v3 ad=0.1936p pd=1.76u as=0.1496p ps=1.12u w=0.44u l=0.28u
X2291 a_5830_2115# a_5799_1609# VDD VDD pfet_03v3 ad=0.1936p pd=1.76u as=0.1496p ps=1.12u w=0.44u l=0.28u
X2292 a_2720_29515# WL[26] WBL[1] VSS nfet_03v3 ad=0.1397p pd=1.22u as=0.1706p ps=1.7u w=0.32u l=0.28u
X2293 RBL[41] a_2689_5993# A[5] VDD pfet_03v3 ad=0.2082p pd=1.84u as=0.2024p ps=1.8u w=0.44u l=0.28u
X2294 RBL[143] a_6421_19145# VSS VSS nfet_03v3 ad=0.1516p pd=1.64u as=0.1516p ps=1.64u w=0.22u l=0.28u
X2295 a_3342_31707# WL[28] WBL[2] VSS nfet_03v3 ad=0.1397p pd=1.22u as=0.1706p ps=1.7u w=0.32u l=0.28u
X2296 RBL[55] a_6421_7089# A[6] VDD pfet_03v3 ad=0.2082p pd=1.84u as=0.2024p ps=1.8u w=0.44u l=0.28u
X2297 RBL[63] a_6421_8185# A[7] VDD pfet_03v3 ad=0.2082p pd=1.84u as=0.2024p ps=1.8u w=0.44u l=0.28u
X2298 VSS a_2098_13075# a_2067_12569# VSS nfet_03v3 ad=0.1108p pd=1.1u as=0.139p ps=1.215u w=0.22u l=0.28u
X2299 VSS a_2098_14171# a_2067_13665# VSS nfet_03v3 ad=0.1108p pd=1.1u as=0.139p ps=1.215u w=0.22u l=0.28u
X2300 a_5830_26227# WL[23] WBL[6] VSS nfet_03v3 ad=0.1397p pd=1.22u as=0.1706p ps=1.7u w=0.32u l=0.28u
X2301 RBL[246] a_5830_33899# A[30] VSS nfet_03v3 ad=0.1516p pd=1.64u as=0.1516p ps=1.64u w=0.22u l=0.28u
X2302 a_5830_25131# WL[22] WBL[6] VSS nfet_03v3 ad=0.1397p pd=1.22u as=0.1706p ps=1.7u w=0.32u l=0.28u
X2303 VDD a_5830_5403# a_5799_4897# VDD pfet_03v3 ad=0.1496p pd=1.12u as=0.1936p ps=1.76u w=0.44u l=0.28u
.ends
