** sch_path: /workspace/analog/tb/8T_open_tb.sch
**.subckt 8T_open_tb vdd vss wl q qb a rbl wbl wblb qin qbin
*.ipin vdd
*.ipin vss
*.ipin wl
*.opin q
*.opin qb
*.ipin a
*.opin rbl
*.ipin wbl
*.ipin wblb
*.ipin qin
*.ipin qbin
x1 vdd vss wl q qb a rbl wbl wblb qin qbin 9T_03v3
**.ends

* expanding   symbol:  /workspace/analog/designs/8T_03v3.sym # of pins=11
.subckt 9T_03v3 VDD VSS WL Q QB A RBL WBL WBLB QIN QBIN
.option scale=5n

X0 Q QBIN VDD VDD pfet_03v3 ad=7.216n pd=0.34m as=4.576n ps=0.192m w=88 l=56
X1 RBL QB A VDD pfet_03v3 ad=8.096n pd=0.36m as=8.096n ps=0.36m w=88 l=56
X2 Q WL WBL VSS nfet_03v3 ad=5.144n pd=0.231m as=5.248n ps=0.292m w=64 l=56
X3 VSS QIN QB VSS nfet_03v3 ad=3.528n pd=0.188m as=5.144n ps=0.231m w=44 l=56
X4 Q QBIN VSS VSS nfet_03v3 ad=5.144n pd=0.231m as=3.528n ps=0.188m w=44 l=56
X5 VSS QB RBL VSS nfet_03v3 ad=5.52n pd=0.316m as=3.436n ps=0.183m w=44 l=56
X6 RBL Q A VSS nfet_03v3 ad=3.436n pd=0.183m as=6.064n ps=0.328m w=44 l=56
X7 VDD QIN QB VDD pfet_03v3 ad=4.576n pd=0.192m as=7.216n ps=0.34m w=88 l=56
X8 QB WL WBLB VSS nfet_03v3 ad=5.144n pd=0.231m as=5.248n ps=0.292m w=64 l=56
C0 Q WBLB 0
C1 WL QB 0.02838f
C2 WL VDD 0.00598f
C3 QB VDD 0.39156f
C4 Q WL 0.02325f
C5 Q QB 0.42649f
C6 Q VDD 0.29815f
C7 RBL QB 0.02564f
C8 RBL VDD 0.09671f
C9 Q RBL 0.00442f
C10 A QB 0.01941f
C11 A VDD 0.07806f
C12 A Q 0.27592f
C13 A RBL 0.11388f
C14 WBL WL 0.0041f
C15 WBL QB 0
C16 WBL VDD 0
C17 Q WBL 0.03151f
C18 WBLB WL 0.00409f
C19 WBLB QB 0.02424f
C20 WBLB VDD 0
C21 WBL VSS 0.16527f
C22 WBLB VSS 0.0821f
C23 WL VSS 0.37209f
C24 RBL VSS 0.07412f
C25 A VSS 0.01169f
C26 QB VSS 0.51978f
C27 Q VSS 0.38737f
C28 VDD VSS 1.09191f
.ends

.end
