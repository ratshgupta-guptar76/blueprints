** sch_path: /workspace/analog/tb/col_64_tb.sch
**.subckt col_64_tb vdd vss wbl
*+ wl[63],wl[62],wl[61],wl[60],wl[59],wl[58],wl[57],wl[56],wl[55],wl[54],wl[53],wl[52],wl[51],wl[50],wl[49],wl[48],wl[47],wl[46],wl[45],wl[44],wl[43],wl[42],wl[41],wl[40],wl[39],wl[38],wl[37],wl[36],wl[35],wl[34],wl[33],wl[32],wl[31],wl[30],wl[29],wl[28],wl[27],wl[26],wl[25],wl[24],wl[23],wl[22],wl[21],wl[20],wl[19],wl[18],wl[17],wl[16],wl[15],wl[14],wl[13],wl[12],wl[11],wl[10],wl[9],wl[8],wl[7],wl[6],wl[5],wl[4],wl[3],wl[2],wl[1],wl[0] wblb
*+ a[63],a[62],a[61],a[60],a[59],a[58],a[57],a[56],a[55],a[54],a[53],a[52],a[51],a[50],a[49],a[48],a[47],a[46],a[45],a[44],a[43],a[42],a[41],a[40],a[39],a[38],a[37],a[36],a[35],a[34],a[33],a[32],a[31],a[30],a[29],a[28],a[27],a[26],a[25],a[24],a[23],a[22],a[21],a[20],a[19],a[18],a[17],a[16],a[15],a[14],a[13],a[12],a[11],a[10],a[9],a[8],a[7],a[6],a[5],a[4],a[3],a[2],a[1],a[0] rbl
*.ipin vdd
*.ipin vss
*.ipin wbl
*.ipin
*+ wl[63],wl[62],wl[61],wl[60],wl[59],wl[58],wl[57],wl[56],wl[55],wl[54],wl[53],wl[52],wl[51],wl[50],wl[49],wl[48],wl[47],wl[46],wl[45],wl[44],wl[43],wl[42],wl[41],wl[40],wl[39],wl[38],wl[37],wl[36],wl[35],wl[34],wl[33],wl[32],wl[31],wl[30],wl[29],wl[28],wl[27],wl[26],wl[25],wl[24],wl[23],wl[22],wl[21],wl[20],wl[19],wl[18],wl[17],wl[16],wl[15],wl[14],wl[13],wl[12],wl[11],wl[10],wl[9],wl[8],wl[7],wl[6],wl[5],wl[4],wl[3],wl[2],wl[1],wl[0]
*.ipin wblb
*.ipin
*+ a[63],a[62],a[61],a[60],a[59],a[58],a[57],a[56],a[55],a[54],a[53],a[52],a[51],a[50],a[49],a[48],a[47],a[46],a[45],a[44],a[43],a[42],a[41],a[40],a[39],a[38],a[37],a[36],a[35],a[34],a[33],a[32],a[31],a[30],a[29],a[28],a[27],a[26],a[25],a[24],a[23],a[22],a[21],a[20],a[19],a[18],a[17],a[16],a[15],a[14],a[13],a[12],a[11],a[10],a[9],a[8],a[7],a[6],a[5],a[4],a[3],a[2],a[1],a[0]
*.opin rbl
x1 vdd vss wbl wl[63] wl[62] wl[61] wl[60] wl[59] wl[58] wl[57] wl[56] wl[55] wl[54] wl[53] wl[52] wl[51] wl[50] wl[49] wl[48]
+ wl[47] wl[46] wl[45] wl[44] wl[43] wl[42] wl[41] wl[40] wl[39] wl[38] wl[37] wl[36] wl[35] wl[34] wl[33] wl[32] wl[31] wl[30] wl[29]
+ wl[28] wl[27] wl[26] wl[25] wl[24] wl[23] wl[22] wl[21] wl[20] wl[19] wl[18] wl[17] wl[16] wl[15] wl[14] wl[13] wl[12] wl[11] wl[10]
+ wl[9] wl[8] wl[7] wl[6] wl[5] wl[4] wl[3] wl[2] wl[1] wl[0] wblb a[63] a[62] a[61] a[60] a[59] a[58] a[57] a[56] a[55] a[54] a[53]
+ a[52] a[51] a[50] a[49] a[48] a[47] a[46] a[45] a[44] a[43] a[42] a[41] a[40] a[39] a[38] a[37] a[36] a[35] a[34] a[33] a[32] a[31]
+ a[30] a[29] a[28] a[27] a[26] a[25] a[24] a[23] a[22] a[21] a[20] a[19] a[18] a[17] a[16] a[15] a[14] a[13] a[12] a[11] a[10] a[9] a[8]
+ a[7] a[6] a[5] a[4] a[3] a[2] a[1] a[0] rbl col_64
**.ends

* expanding   symbol:  analog/designs/col_64.sym # of pins=7
** sym_path: /workspace/analog/designs/col_64.sym
** sch_path: /workspace/analog/designs/col_64.sch
.subckt col_64 vdd vss wbl wl[63] wl[62] wl[61] wl[60] wl[59] wl[58] wl[57] wl[56] wl[55] wl[54] wl[53] wl[52] wl[51] wl[50]
+ wl[49] wl[48] wl[47] wl[46] wl[45] wl[44] wl[43] wl[42] wl[41] wl[40] wl[39] wl[38] wl[37] wl[36] wl[35] wl[34] wl[33] wl[32] wl[31]
+ wl[30] wl[29] wl[28] wl[27] wl[26] wl[25] wl[24] wl[23] wl[22] wl[21] wl[20] wl[19] wl[18] wl[17] wl[16] wl[15] wl[14] wl[13] wl[12]
+ wl[11] wl[10] wl[9] wl[8] wl[7] wl[6] wl[5] wl[4] wl[3] wl[2] wl[1] wl[0] wblb a[63] a[62] a[61] a[60] a[59] a[58] a[57] a[56] a[55]
+ a[54] a[53] a[52] a[51] a[50] a[49] a[48] a[47] a[46] a[45] a[44] a[43] a[42] a[41] a[40] a[39] a[38] a[37] a[36] a[35] a[34] a[33]
+ a[32] a[31] a[30] a[29] a[28] a[27] a[26] a[25] a[24] a[23] a[22] a[21] a[20] a[19] a[18] a[17] a[16] a[15] a[14] a[13] a[12] a[11]
+ a[10] a[9] a[8] a[7] a[6] a[5] a[4] a[3] a[2] a[1] a[0] rbl
*.ipin vdd
*.ipin wbl
*.ipin wblb
*.ipin vss
*.opin rbl
*.ipin
*+ wl[63],wl[62],wl[61],wl[60],wl[59],wl[58],wl[57],wl[56],wl[55],wl[54],wl[53],wl[52],wl[51],wl[50],wl[49],wl[48],wl[47],wl[46],wl[45],wl[44],wl[43],wl[42],wl[41],wl[40],wl[39],wl[38],wl[37],wl[36],wl[35],wl[34],wl[33],wl[32],wl[31],wl[30],wl[29],wl[28],wl[27],wl[26],wl[25],wl[24],wl[23],wl[22],wl[21],wl[20],wl[19],wl[18],wl[17],wl[16],wl[15],wl[14],wl[13],wl[12],wl[11],wl[10],wl[9],wl[8],wl[7],wl[6],wl[5],wl[4],wl[3],wl[2],wl[1],wl[0]
*.ipin
*+ a[63],a[62],a[61],a[60],a[59],a[58],a[57],a[56],a[55],a[54],a[53],a[52],a[51],a[50],a[49],a[48],a[47],a[46],a[45],a[44],a[43],a[42],a[41],a[40],a[39],a[38],a[37],a[36],a[35],a[34],a[33],a[32],a[31],a[30],a[29],a[28],a[27],a[26],a[25],a[24],a[23],a[22],a[21],a[20],a[19],a[18],a[17],a[16],a[15],a[14],a[13],a[12],a[11],a[10],a[9],a[8],a[7],a[6],a[5],a[4],a[3],a[2],a[1],a[0]
x[63] vdd wbl wblb vss wl[63] a[63] qb[63] q[63] qb[63] rbl q[63] 8T_03v3
x[62] vdd wbl wblb vss wl[62] a[62] qb[62] q[62] qb[62] rbl q[62] 8T_03v3
x[61] vdd wbl wblb vss wl[61] a[61] qb[61] q[61] qb[61] rbl q[61] 8T_03v3
x[60] vdd wbl wblb vss wl[60] a[60] qb[60] q[60] qb[60] rbl q[60] 8T_03v3
x[59] vdd wbl wblb vss wl[59] a[59] qb[59] q[59] qb[59] rbl q[59] 8T_03v3
x[58] vdd wbl wblb vss wl[58] a[58] qb[58] q[58] qb[58] rbl q[58] 8T_03v3
x[57] vdd wbl wblb vss wl[57] a[57] qb[57] q[57] qb[57] rbl q[57] 8T_03v3
x[56] vdd wbl wblb vss wl[56] a[56] qb[56] q[56] qb[56] rbl q[56] 8T_03v3
x[55] vdd wbl wblb vss wl[55] a[55] qb[55] q[55] qb[55] rbl q[55] 8T_03v3
x[54] vdd wbl wblb vss wl[54] a[54] qb[54] q[54] qb[54] rbl q[54] 8T_03v3
x[53] vdd wbl wblb vss wl[53] a[53] qb[53] q[53] qb[53] rbl q[53] 8T_03v3
x[52] vdd wbl wblb vss wl[52] a[52] qb[52] q[52] qb[52] rbl q[52] 8T_03v3
x[51] vdd wbl wblb vss wl[51] a[51] qb[51] q[51] qb[51] rbl q[51] 8T_03v3
x[50] vdd wbl wblb vss wl[50] a[50] qb[50] q[50] qb[50] rbl q[50] 8T_03v3
x[49] vdd wbl wblb vss wl[49] a[49] qb[49] q[49] qb[49] rbl q[49] 8T_03v3
x[48] vdd wbl wblb vss wl[48] a[48] qb[48] q[48] qb[48] rbl q[48] 8T_03v3
x[47] vdd wbl wblb vss wl[47] a[47] qb[47] q[47] qb[47] rbl q[47] 8T_03v3
x[46] vdd wbl wblb vss wl[46] a[46] qb[46] q[46] qb[46] rbl q[46] 8T_03v3
x[45] vdd wbl wblb vss wl[45] a[45] qb[45] q[45] qb[45] rbl q[45] 8T_03v3
x[44] vdd wbl wblb vss wl[44] a[44] qb[44] q[44] qb[44] rbl q[44] 8T_03v3
x[43] vdd wbl wblb vss wl[43] a[43] qb[43] q[43] qb[43] rbl q[43] 8T_03v3
x[42] vdd wbl wblb vss wl[42] a[42] qb[42] q[42] qb[42] rbl q[42] 8T_03v3
x[41] vdd wbl wblb vss wl[41] a[41] qb[41] q[41] qb[41] rbl q[41] 8T_03v3
x[40] vdd wbl wblb vss wl[40] a[40] qb[40] q[40] qb[40] rbl q[40] 8T_03v3
x[39] vdd wbl wblb vss wl[39] a[39] qb[39] q[39] qb[39] rbl q[39] 8T_03v3
x[38] vdd wbl wblb vss wl[38] a[38] qb[38] q[38] qb[38] rbl q[38] 8T_03v3
x[37] vdd wbl wblb vss wl[37] a[37] qb[37] q[37] qb[37] rbl q[37] 8T_03v3
x[36] vdd wbl wblb vss wl[36] a[36] qb[36] q[36] qb[36] rbl q[36] 8T_03v3
x[35] vdd wbl wblb vss wl[35] a[35] qb[35] q[35] qb[35] rbl q[35] 8T_03v3
x[34] vdd wbl wblb vss wl[34] a[34] qb[34] q[34] qb[34] rbl q[34] 8T_03v3
x[33] vdd wbl wblb vss wl[33] a[33] qb[33] q[33] qb[33] rbl q[33] 8T_03v3
x[32] vdd wbl wblb vss wl[32] a[32] qb[32] q[32] qb[32] rbl q[32] 8T_03v3
x[31] vdd wbl wblb vss wl[31] a[31] qb[31] q[31] qb[31] rbl q[31] 8T_03v3
x[30] vdd wbl wblb vss wl[30] a[30] qb[30] q[30] qb[30] rbl q[30] 8T_03v3
x[29] vdd wbl wblb vss wl[29] a[29] qb[29] q[29] qb[29] rbl q[29] 8T_03v3
x[28] vdd wbl wblb vss wl[28] a[28] qb[28] q[28] qb[28] rbl q[28] 8T_03v3
x[27] vdd wbl wblb vss wl[27] a[27] qb[27] q[27] qb[27] rbl q[27] 8T_03v3
x[26] vdd wbl wblb vss wl[26] a[26] qb[26] q[26] qb[26] rbl q[26] 8T_03v3
x[25] vdd wbl wblb vss wl[25] a[25] qb[25] q[25] qb[25] rbl q[25] 8T_03v3
x[24] vdd wbl wblb vss wl[24] a[24] qb[24] q[24] qb[24] rbl q[24] 8T_03v3
x[23] vdd wbl wblb vss wl[23] a[23] qb[23] q[23] qb[23] rbl q[23] 8T_03v3
x[22] vdd wbl wblb vss wl[22] a[22] qb[22] q[22] qb[22] rbl q[22] 8T_03v3
x[21] vdd wbl wblb vss wl[21] a[21] qb[21] q[21] qb[21] rbl q[21] 8T_03v3
x[20] vdd wbl wblb vss wl[20] a[20] qb[20] q[20] qb[20] rbl q[20] 8T_03v3
x[19] vdd wbl wblb vss wl[19] a[19] qb[19] q[19] qb[19] rbl q[19] 8T_03v3
x[18] vdd wbl wblb vss wl[18] a[18] qb[18] q[18] qb[18] rbl q[18] 8T_03v3
x[17] vdd wbl wblb vss wl[17] a[17] qb[17] q[17] qb[17] rbl q[17] 8T_03v3
x[16] vdd wbl wblb vss wl[16] a[16] qb[16] q[16] qb[16] rbl q[16] 8T_03v3
x[15] vdd wbl wblb vss wl[15] a[15] qb[15] q[15] qb[15] rbl q[15] 8T_03v3
x[14] vdd wbl wblb vss wl[14] a[14] qb[14] q[14] qb[14] rbl q[14] 8T_03v3
x[13] vdd wbl wblb vss wl[13] a[13] qb[13] q[13] qb[13] rbl q[13] 8T_03v3
x[12] vdd wbl wblb vss wl[12] a[12] qb[12] q[12] qb[12] rbl q[12] 8T_03v3
x[11] vdd wbl wblb vss wl[11] a[11] qb[11] q[11] qb[11] rbl q[11] 8T_03v3
x[10] vdd wbl wblb vss wl[10] a[10] qb[10] q[10] qb[10] rbl q[10] 8T_03v3
x[9] vdd wbl wblb vss wl[9] a[9] qb[9] q[9] qb[9] rbl q[9] 8T_03v3
x[8] vdd wbl wblb vss wl[8] a[8] qb[8] q[8] qb[8] rbl q[8] 8T_03v3
x[7] vdd wbl wblb vss wl[7] a[7] qb[7] q[7] qb[7] rbl q[7] 8T_03v3
x[6] vdd wbl wblb vss wl[6] a[6] qb[6] q[6] qb[6] rbl q[6] 8T_03v3
x[5] vdd wbl wblb vss wl[5] a[5] qb[5] q[5] qb[5] rbl q[5] 8T_03v3
x[4] vdd wbl wblb vss wl[4] a[4] qb[4] q[4] qb[4] rbl q[4] 8T_03v3
x[3] vdd wbl wblb vss wl[3] a[3] qb[3] q[3] qb[3] rbl q[3] 8T_03v3
x[2] vdd wbl wblb vss wl[2] a[2] qb[2] q[2] qb[2] rbl q[2] 8T_03v3
x[1] vdd wbl wblb vss wl[1] a[1] qb[1] q[1] qb[1] rbl q[1] 8T_03v3
x[0] vdd wbl wblb vss wl[0] a[0] qb[0] q[0] qb[0] rbl q[0] 8T_03v3
.ends

* expanding   symbol:  analog/designs/8T_03v3.sym # of pins=11
** sym_path: /workspace/analog/designs/8T_03v3.sym
** sch_path: /workspace/analog/designs/8T_03v3.sch
.subckt 8T_03v3 VDD WBL WBLB VSS WL A QIN Q QB RBL QBIN
*.ipin A
*.opin RBL
*.ipin VSS
*.ipin VDD
*.ipin WL
*.ipin WBL
*.ipin WBLB
*.ipin QBIN
*.ipin QIN
*.opin Q
*.opin QB
XM1 net1 Q VSS VSS nfet_03v3 L='L_M1' W='W_M1' nf=1 ad='int((nf+1)/2) * W/nf * 0.18u' as='int((nf+2)/2) * W/nf * 0.18u' pd='2*int((nf+1)/2) * (W/nf + 0.18u)'
+ ps='2*int((nf+2)/2) * (W/nf + 0.18u)' nrd='0.18u / W' nrs='0.18u / W' sa=0 sb=0 sd=0
XM2 RBL A net1 VSS nfet_03v3 L='L_M2' W='W_M2' nf=1 ad='int((nf+1)/2) * W/nf * 0.18u' as='int((nf+2)/2) * W/nf * 0.18u' pd='2*int((nf+1)/2) * (W/nf + 0.18u)'
+ ps='2*int((nf+2)/2) * (W/nf + 0.18u)' nrd='0.18u / W' nrs='0.18u / W' sa=0 sb=0 sd=0
XPD1 QB QBIN VSS VSS nfet_03v3 L='L_PD' W='W_PD' nf=1 ad='int((nf+1)/2) * W/nf * 0.18u' as='int((nf+2)/2) * W/nf * 0.18u' pd='2*int((nf+1)/2) * (W/nf + 0.18u)'
+ ps='2*int((nf+2)/2) * (W/nf + 0.18u)' nrd='0.18u / W' nrs='0.18u / W' sa=0 sb=0 sd=0
XPU1 QB QBIN VDD VDD pfet_03v3 L='L_PU' W='W_PU' nf=1 ad='int((nf+1)/2) * W/nf * 0.18u' as='int((nf+2)/2) * W/nf * 0.18u' pd='2*int((nf+1)/2) * (W/nf + 0.18u)'
+ ps='2*int((nf+2)/2) * (W/nf + 0.18u)' nrd='0.18u / W' nrs='0.18u / W' sa=0 sb=0 sd=0
XAX1 WBLB WL QB VSS nfet_03v3 L='L_AX' W='W_AX' nf=1 ad='int((nf+1)/2) * W/nf * 0.18u' as='int((nf+2)/2) * W/nf * 0.18u' pd='2*int((nf+1)/2) * (W/nf + 0.18u)'
+ ps='2*int((nf+2)/2) * (W/nf + 0.18u)' nrd='0.18u / W' nrs='0.18u / W' sa=0 sb=0 sd=0
XPU2 Q QIN VDD VDD pfet_03v3 L='L_PU' W='W_PU' nf=1 ad='int((nf+1)/2) * W/nf * 0.18u' as='int((nf+2)/2) * W/nf * 0.18u' pd='2*int((nf+1)/2) * (W/nf + 0.18u)'
+ ps='2*int((nf+2)/2) * (W/nf + 0.18u)' nrd='0.18u / W' nrs='0.18u / W' sa=0 sb=0 sd=0
XPD2 Q QIN VSS VSS nfet_03v3 L='L_PD' W='W_PD' nf=1 ad='int((nf+1)/2) * W/nf * 0.18u' as='int((nf+2)/2) * W/nf * 0.18u' pd='2*int((nf+1)/2) * (W/nf + 0.18u)'
+ ps='2*int((nf+2)/2) * (W/nf + 0.18u)' nrd='0.18u / W' nrs='0.18u / W' sa=0 sb=0 sd=0
XAX2 WBL WL Q VSS nfet_03v3 L='L_AX' W='W_AX' nf=1 ad='int((nf+1)/2) * W/nf * 0.18u' as='int((nf+2)/2) * W/nf * 0.18u' pd='2*int((nf+1)/2) * (W/nf + 0.18u)'
+ ps='2*int((nf+2)/2) * (W/nf + 0.18u)' nrd='0.18u / W' nrs='0.18u / W' sa=0 sb=0 sd=0
.ends

.end
