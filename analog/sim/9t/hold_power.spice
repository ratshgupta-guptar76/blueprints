* ============================================
* Test: hold_power.spice
* Cell: 8T_03v3
* PDK: GF180mcuD
* ============================================
* Same stimulus as hold_run.spice (idle cell, RBL parked at 0V, A held HI)
* but reports average VDD supply current -> static/leakage hold power
* instead of just the endpoint logic levels.

* -- includes --
.include /workspace/analog/designs/pvt.spice
.include /workspace/analog/designs/params_6T.spice
.include /workspace/analog/designs/params_8T.spice
.include /workspace/analog/tb/9T_tb.spice

* -- stimulus --
VVDD vdd  0 {VDD_CORNER}  ; supply
VVSS vss  0 0             ; gnd
VWL  wl   0 0             ; hold: OFF
VBL  wbl  0 0             ; bitlines parked (or floating)
VBLB wblb 0 0             ; bitlines parked (or floating)
VRBL rbl  0 0             ; bitline parked
VA   a    0 {VDD_CORNER}        ; set Activation = HI

* -- initial conditions --
.ic v(q)={VDD_CORNER} v(qb)=0       ; initial state: Q=1, QB=0

* .control params -- {} substitution inside .control needs a .csparam bridge
.csparam VDD_CORNER={VDD_CORNER}

* -- sim --
.control
  save all

  tran 0.1n 50n uic

  * --- average VDD supply current once transients have settled ---
  echo
  meas tran i_hold_avg AVG i(vvdd) FROM=20n TO=50n
  let p_hold = abs(i_hold_avg) * {VDD_CORNER}
  print p_hold
  echo

  * --- save .raw for python parsing ---
  write /workspace/analog/sim/9t/results/hold_power.raw all

.endc

.end
