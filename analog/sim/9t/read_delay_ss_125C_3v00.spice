* ============================================
* Test: read_delay_ss_125C_3v00.spice
* Cell: 9T_03v3
* PDK: GF180mcuD
* ============================================
* Liberty (ss_125C_3v00) characterization variant of read_delay.spice:
* same A -> RBL propagation-delay measurement as read_delay_tt_025C_3v30.spice,
* at the ss/125C/3.0V corner (pvt_ss_125C_3v00.spice) instead of typical,
* with CRBL set to the same real worst-case extracted RBL net capacitance
* from the sram_32x8_9T macro's SPEF (max over all 256 RBL[i] nets, from
* ip/sram_32x8_9T/spef/sram_32x8_9T.spef) -- capacitance is a geometric
* extraction result, not corner-dependent, so it's unchanged across corners.
* Confirmed by inspecting the transient waveform (RBL tracks A while Q=1,
* i.e. RBL = A*Q -- the expected charge-domain multiply): RBL RISES in
* response to A's rising edge and FALLS in response to A's falling edge,
* so each edge is measured against its own causal A transition (not both
* against A's rising edge, which would time the fall against an unrelated
* trigger). Also measures RBL's own 20-80% transition time each way.

* -- includes --
.include /workspace/analog/designs/pvt_ss_125C_3v00.spice
.include /workspace/analog/designs/params_6T.spice
.include /workspace/analog/designs/params_8T.spice
.include /workspace/analog/tb/9T_tb.spice

* -- stimulus --
VVDD vdd  0 {VDD_CORNER}
VVSS vss  0 0
VWL  wl   0 0                                              ; write port off
VBL  wbl  0 0
VBLB wblb 0 0
VA   a    0 PULSE(0 {VDD_CORNER} 5n 0.1n 0.1n 20n 50n)     ; activation pulsed
CRBL rbl  0 3.52894f    ; real extracted max RBL net cap (sram_32x8_9T SPEF)

* -- initial conditions --
.ic v(q)={VDD_CORNER} v(qb)=0    ; W=1 stored

* .control params -- {} substitution inside .control needs a .csparam bridge
.csparam VDD_CORNER={VDD_CORNER}

* -- sim --
.control
  save all

  tran 0.01n 50n uic

  * --- A -> RBL propagation delay + transition, both edges ---
  echo
  * TD=4n on every trig/targ: see write_delay_tt_025C_3v30.spice's comment --
  * uic-mode start leaves non-.ic nodes inconsistent, producing a startup
  * transient in the first few ns that a plain threshold search can mistake
  * for a real crossing. Gating past it (well before the real edges at 5n)
  * avoids that even though this particular waveform happened not to trip it.
  meas tran t_read_rise   TRIG v(a) VAL={VDD_CORNER}/2 RISE=1 TD=4n TARG v(rbl) VAL={VDD_CORNER}/2   RISE=1 TD=4n
  meas tran t_read_fall   TRIG v(a) VAL={VDD_CORNER}/2 FALL=1 TD=4n TARG v(rbl) VAL={VDD_CORNER}/2   FALL=1 TD=4n
  meas tran trans_rbl_rise TRIG v(rbl) VAL='0.2*{VDD_CORNER}' RISE=1 TD=4n TARG v(rbl) VAL='0.8*{VDD_CORNER}' RISE=1 TD=4n
  meas tran trans_rbl_fall TRIG v(rbl) VAL='0.8*{VDD_CORNER}' FALL=1 TD=4n TARG v(rbl) VAL='0.2*{VDD_CORNER}' FALL=1 TD=4n
  echo

  * --- save .raw for python parsing ---
  write /workspace/analog/sim/9t/results/read_delay_ss_125C_3v00.raw all

.endc

.end
