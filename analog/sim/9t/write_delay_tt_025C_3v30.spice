* ============================================
* Test: write_delay_tt_025C_3v30.spice
* Cell: 9T_03v3
* PDK: GF180mcuD
* ============================================
* Liberty (tt_025C_3v30) characterization variant of write_delay.spice:
* same WL -> Q propagation-delay measurement (full-VDD write, Q: 1 -> 0),
* at the typical corner (pvt_tt_025C_3v30.spice) instead of ss/-40C/3.67V.
* Informational only -- Q isn't an exposed macro pin, so this doesn't map
* to a Liberty timing arc directly, but it's real silicon-grounded data
* worth keeping alongside the read numbers.

* -- includes --
.include /workspace/analog/designs/pvt_tt_025C_3v30.spice
.include /workspace/analog/designs/params_6T.spice
.include /workspace/analog/designs/params_8T.spice
.include /workspace/analog/tb/9T_tb.spice

* -- stimulus --
VVDD  vdd 0 {VDD_CORNER}                        ; supply
VVSS  vss 0 0                                   ; source
VWL   wl  0 PULSE(0 {VDD_CORNER} 5n 0.1n 0.1n 20n 50n)   ; write: ON - Pulsed
VWBL  wbl  0 0                                  ; WBL LOW pulls Q down
VWBLB wblb 0 {VDD_CORNER}                                ; WBLB HIGH pulls QB up
VA    a   0 {VDD_CORNER}                                 ; set Activation = HI
CRBL  rbl 0 3.52894f    ; real extracted max RBL net cap (sram_32x8_9T SPEF) --
                        ; the original write_delay.spice left rbl fully
                        ; floating, which (never having actually been run
                        ; before) let Q/QB drift to a nonphysical ~0.45V
                        ; midpoint well before WL ever fires; see below.

* -- initial conditions --
.ic v(q)={VDD_CORNER} v(qb)=0    ; initial state: Q=1, QB=0

* .control params -- {} substitution inside .control needs a .csparam bridge
.csparam VDD_CORNER={VDD_CORNER}

* -- sim --
.control
  save all

  tran 0.01n 50n uic

  * --- WL -> Q propagation delay (full-VDD write, not the bisection margin) ---
  * TD=4n on both edges: uic-mode start only sets .ic on Q/QB, leaving every
  * other node (parasitic caps, transistor terminals) at an inconsistent 0V,
  * which produces a large non-physical startup transient (Q briefly swings
  * >VDD then undershoots below VDD/2) that a plain FALL=1 search picks up
  * as a spurious ~0.06ns crossing, giving a nonsensical negative delay.
  * Gating the search to start after the transient has settled (well before
  * the real WL edge at 5n) finds the real crossing instead.
  echo
  meas tran t_write TRIG v(wl) VAL={VDD_CORNER}/2 RISE=1 TD=4n TARG v(q) VAL={VDD_CORNER}/2 FALL=1 TD=4n
  echo

  * --- save .raw for python parsing ---
  write /workspace/analog/sim/9t/results/write_delay_tt_025C_3v30.raw all

.endc

.end
