DC Sweep — Compute-port transfer characteristic (activation sweep)
* ============================================
* Test: mult_dc_sweep.spice
* Cell: 8T_03v3
* PDK: GF180mcuD
* Purpose: RBL vs activation transfer curve, per stored weight.
*          Characterizes product-bit transition sharpness (Rung 1).
* ============================================

* -- includes --
.include /workspace/analog/designs/pvt.spice
.include /workspace/analog/designs/params_6T.spice
.include /workspace/analog/designs/params_8T.spice
.include /workspace/analog/tb/9T_tb.spice

* -- static bias --
VVDD vdd  0 {VDD_CORNER}   ; supply
VVSS vss  0 0              ; source
VWL  wl   0 0             ; reads: OFF
VBL  wbl  0 0             ; bitlines parked
VBLB wblb 0 0             ; bitlines parked

* -- activation is the swept source --
VA   a    0 0             ; DC value overridden by .dc sweep

* -- stored weight set by initial condition (see note on DC + .ic below) --
.ic v(q)=0 v(qb)={VDD_CORNER}    ; weight = 1  (edit to q=0 for the weight=0 curve)

.control
  save all

  * --- sweep activation 0 -> VDD, fine step ---
  VA a 0 PWL(0 0  5n 0  95n {VDD_CORNER}  100n {VDD_CORNER})

  * --- transition metrics ---
  * midpoint: activation where rbl crosses VDD/2
  meas dc a_trip   WHEN v(rbl)={VDD_CORNER/2}
  * levels at the rails of the sweep
  meas dc rbl_lo   FIND v(rbl) AT=0
  meas dc rbl_hi   FIND v(rbl) AT={VDD_CORNER}
  * max slope (steepness of the transition = "gain")
  let grbl = deriv(v(rbl))
  meas dc max_slope MAX abs(grbl)

  * --- plot the transfer curve ---
  plot v(rbl) vs v(a)
  + title "RBL vs Activation (weight=1)"
  + xlabel "activation (V)"
  + ylabel "rbl (V)"

  write /workspace/analog/sim/9t/results/mult_dc_sweep_w1.raw all
.endc

.end
