Monte Carlo Simulation on 8T SRAM (AND) bitcell
* ============================================
* Test: monte_carlo.spice
* Cell: 8T_03v3
* PDK: GF180mcuD
* Author: R. Gupta
* Date: 2026-07-14
* ============================================

* -- includes --
.include /workspace/analog/designs/pvt.spice
.include /workspace/analog/designs/params_6T.spice
.include /workspace/analog/designs/params_8T.spice
.include /workspace/analog/tb/8T_open_tb.spice

* -- stimulus --
VVDD vdd 0 {VDD_CORNER}   ; supply
VVSS vss 0 0              ; source
VWL  wl  0 0              ; hold: OFF
VU   u   0 0              ; input voltage to be swept
VA   a   0 {VDD_CORNER}   ; set Activation = HI

* -- initial conditions --
.ic v(q)={VDD_CORNER} v(qb)=0         ; initial state: Q=1, QB=0
.ic v(wbl)=0.1 v(wblb)=0.1   ; initial state pre-charged to 0.1V - common for idle power reduction

* -- SNM rotation transformation --
BV1 v1   0 v= sqrt(2)*v(q)+v(u)
BV2 v2   0 v= sqrt(2)*v(qb)-v(u)
BQ  qin  0 v=(v(v1)+v(u))* 1/sqrt(2)  ; input to inverter Q
BQB qbin 0 v=(v(v2)-v(u))* 1/sqrt(2)  ; input to inverter QB

* .control params
.csparam VDD_CORNER={VDD_CORNER}

.option noacct
* -- analysis --
.control
  save all

  * --- DC sweep the original input voltage ---
  let VDD_HALF_HI={VDD_CORNER} / 2
  let VDD_HALF_LO={VDD_CORNER} / -2
  dc VU $&VDD_HALF_LO $&VDD_HALF_HI 0.01

  * plot v(q) v(qb)
  * --- variables for SNM calculation ---
  let diff = (v(v1) - v(v2))/sqrt(2)

  * --- measure data ---
  echo
  meas DC hold_snm_max MAX diff
  meas DC hold_snm_min MIN diff
  echo
  let hold_snm = min(abs(hold_snm_max), abs(hold_snm_min))
  print hold_snm
  echo
  * --- save .raw for python parsing ---
  write /workspace/analog/sim/8t/results/hold_snm.raw all

.endc

.end
