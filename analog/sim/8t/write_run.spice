* ============================================
* Test: write_run.spice
* Cell: 8T_03v3
* PDK: GF180mcuD
* Author: R. Gupta
* Date: 2026-06-19
* ============================================

* -- includes --
.include /workspace/analog/designs/pvt.spice
.include /workspace/analog/designs/params_6T.spice
.include /workspace/analog/designs/params_8T.spice
.include /workspace/analog/tb/8T_tb.spice

* -- stimulus --
VVDD  vdd 0 {VDD_CORNER}                        ; supply
VVSS  vss 0 0                                   ; source
VWL   wl  0 PULSE(0 {VDD_CORNER} 5n 0.1n 0.1n 20n 50n)   ; write: ON - Pulsed
VWBL  wbl  0 0                                  ; WBL LOW pulls Q down
VWBLB wblb 0 {VDD_CORNER}                                ; WBLB HIGH pulls QB up
VA    a   0 {VDD_CORNER}                                 ; set Activation = HI

* -- initial conditions --
.ic v(q)={VDD_CORNER} v(qb)=0    ; initial state: Q=1, QB=0

* -- sim --
.control
  save all

  tran 0.1n 50n uic

  * plot v(q) v(qb)

  * --- validate data ---
  echo
  meas tran q_init  FIND v(q)  AT=5n
  meas tran qb_init FIND v(qb) AT=5n
  echo
  meas tran q_final FIND v(q) AT=50n
  meas tran qb_final FIND v(qb) AT=50n
  echo
  * --- save .raw for python parsing ---
  write /workspace/analog/sim/8t/results/write_run.raw all

.endc

.end
