* ============================================
* Test: write_delay.spice
* Cell: 8T_03v3
* PDK: GF180mcuD
* ============================================
* Same stimulus as write_run.spice (full-VDD write, Q: 1 -> 0) but reports
* the WL -> Q propagation delay instead of just the endpoint logic levels.

* -- includes --
.include /workspace/analog/designs/pvt.spice
.include /workspace/analog/designs/params_6T.spice
.include /workspace/analog/designs/params_8T.spice
.include /workspace/analog/tb/8T_tb.spice

* -- stimulus --
VVDD  vdd 0 {VDD_CORNER}                        ; supply
VVSS  vss 0 0                                   ; source
VWL   wl  0 PULSE(0 {VDD_CORNER} 5n 0.1n 0.1n 20n 50n)   ; write: ON - Pulsed
VWBL  wbl  0 0                                  ; WBL LOW pulls Q down
VWBLB wblb 0 {VDD_CORNER}                                ; WBLB HIGH pulls QB up
VA    a   0 {VDD_CORNER}                                 ; set Activation = HI

* -- initial conditions --
.ic v(q)={VDD_CORNER} v(qb)=0    ; initial state: Q=1, QB=0

* .control params -- {} substitution inside .control needs a .csparam bridge
.csparam VDD_CORNER={VDD_CORNER}

* -- sim --
.control
  save all

  tran 0.1n 50n uic

  * --- WL -> Q propagation delay (full-VDD write, not the bisection margin) ---
  echo
  meas tran t_write TRIG v(wl) VAL={VDD_CORNER}/2 RISE=1 TARG v(q) VAL={VDD_CORNER}/2 FALL=1
  echo

  * --- save .raw for python parsing ---
  write /workspace/analog/sim/8t/results/write_delay.raw all

.endc

.end
