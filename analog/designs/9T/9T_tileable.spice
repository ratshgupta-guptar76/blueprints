* NGSPICE file created from 9T_tileable.ext - technology: gf180mcuD

.subckt x9T_tileable WBL WBLB WL A RBL
X0 RBL QB a_199_412# VSUBS nfet_03v3 ad=0.1516p pd=1.64u as=0.1516p ps=1.64u w=0.22u l=0.28u
X1 QB WL WBL VSUBS nfet_03v3 ad=0.139p pd=1.215u as=0.2362p ps=2.03u w=0.32u l=0.28u
X2 Q QB a_103_8# w_n143_n79# pfet_03v3 ad=0.1936p pd=1.76u as=0.1496p ps=1.12u w=0.44u l=0.28u
X3 Q WL WBLB VSUBS nfet_03v3 ad=0.1397p pd=1.22u as=0.1706p ps=1.7u w=0.32u l=0.28u
X4 Q QB a_103_n256# VSUBS nfet_03v3 ad=0.1397p pd=1.22u as=0.1108p ps=1.1u w=0.22u l=0.28u
X5 a_103_8# Q QB w_n143_n79# pfet_03v3 ad=0.1496p pd=1.12u as=0.1936p ps=1.76u w=0.44u l=0.28u
X6 RBL Q A VSUBS nfet_03v3 ad=0.1516p pd=1.64u as=0.1516p ps=1.64u w=0.22u l=0.28u
X7 a_103_n256# Q QB VSUBS nfet_03v3 ad=0.1108p pd=1.1u as=0.139p ps=1.215u w=0.22u l=0.28u
X8 RBL QB A w_n143_n79# pfet_03v3 ad=0.2024p pd=1.8u as=0.2024p ps=1.8u w=0.44u l=0.28u
C0 Q WBL 0.00559f
C1 w_n143_n79# WBLB 0.0027f
C2 a_199_412# WL 0
C3 QB RBL 0.04757f
C4 a_199_412# QB 0.00673f
C5 A RBL 0.47299f
C6 a_103_8# WBL 0.07061f
C7 a_103_n256# WL 0.32869f
C8 w_n143_n79# WL 0.01141f
C9 a_199_412# A 0.02463f
C10 QB a_103_n256# 0.18842f
C11 Q RBL 0.12271f
C12 w_n143_n79# QB 0.14895f
C13 Q a_199_412# 0.00144f
C14 a_103_n256# A 0
C15 a_103_8# RBL 0.09313f
C16 WL WBLB 0.11338f
C17 Q a_103_n256# 0.07522f
C18 w_n143_n79# A 0.03814f
C19 QB WBLB 0.00726f
C20 w_n143_n79# Q 0.22466f
C21 a_103_8# a_103_n256# 0.25969f
C22 RBL WBL 0.003f
C23 A WBLB 0.07019f
C24 w_n143_n79# a_103_8# 0.02192f
C25 Q WBLB 0.02755f
C26 a_199_412# WBL 0.00189f
C27 QB WL 0.03681f
C28 a_103_8# WBLB 0.06885f
C29 A WL 0.00411f
C30 a_103_n256# WBL 0.12027f
C31 w_n143_n79# WBL 0.004f
C32 QB A 0.10531f
C33 a_199_412# RBL 0.15753f
C34 Q WL 0.02719f
C35 Q QB 0.44205f
C36 a_103_8# WL 0.00258f
C37 a_103_n256# RBL 0.03528f
C38 WBL WBLB 0.32269f
C39 w_n143_n79# RBL 0.03494f
C40 QB a_103_8# 0.09414f
C41 Q A 0.06413f
C42 a_103_8# A 0.20811f
C43 WL WBL 0.08047f
C44 RBL WBLB 0.44723f
C45 Q a_103_8# 0.2074f
C46 w_n143_n79# a_103_n256# 0
C47 QB WBL 0.02466f
C48 a_199_412# WBLB 0.00409f
C49 a_103_n256# WBLB 0.11213f
C50 A WBL 0.08034f
C51 RBL WL 0.01815f
C52 WBLB VSUBS 0.11594f
C53 WBL VSUBS 0.45726f
C54 RBL VSUBS 0.65145f
C55 A VSUBS 0.36296f
C56 a_103_n256# VSUBS 0.15477f
C57 a_103_8# VSUBS 0.38993f
C58 a_199_412# VSUBS 0.26227f
C59 w_n143_n79# VSUBS 0.75573f
.ends
