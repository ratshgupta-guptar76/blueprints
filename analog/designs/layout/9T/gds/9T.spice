** sch_path: /workspace/analog/designs/9T_03v3.sch
.subckt 9T RBL VSS VDD WL WBL WBLB Q QB A
*.PININFO RBL:O VSS:I VDD:I WL:I WBL:I WBLB:I Q:O QB:O A:I
XM1 RBL QB VSS VSS nfet_03v3 L=0.28u W=0.22u nf=1
XPD1 QB Q VSS VSS nfet_03v3 L=0.28u W=0.22u nf=1
XPU1 QB Q VDD VDD pfet_03v3 L=0.28u W=0.44u nf=1
XAX1 WBLB WL QB VSS nfet_03v3 L=0.28u W=0.32u nf=1
XAX2 WBL WL Q VSS nfet_03v3 L=0.28u W=0.32u nf=1
XPU2 Q QB VDD VDD pfet_03v3 L=0.28u W=0.44u nf=1
XPD2 Q QB VSS VSS nfet_03v3 L=0.28u W=0.22u nf=1
XM2 RBL QB A VDD pfet_03v3 L=0.28u W=0.44u nf=1
XM3 A Q RBL VSS nfet_03v3 L=0.28u W=0.22u nf=1
.ends
