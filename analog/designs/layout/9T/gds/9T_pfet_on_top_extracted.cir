* Extracted by KLayout with GF180MCU LVS runset on : 07/08/2026 22:00

* cell 9T_pfet_on_top
* pin A
* pin Q
* pin QB
* pin RBL
* pin VSS
* pin VSS
* pin WBL
* pin WBLB
* pin WL
.SUBCKT 9T_pfet_on_top A Q QB RBL VSS VSS$1 WBL WBLB WL
* device instance $1 r0 *1 1.335,0.95 pfet_03v3
M$1 RBL QB A VSS pfet_03v3 L=0.28U W=0.44U AS=0.2024P AD=0.2024P PS=1.8U PD=1.8U
* device instance $2 r0 *1 0.375,0.23 pfet_03v3
M$2 VSS Q QB VSS pfet_03v3 L=0.28U W=0.44U AS=0.1804P AD=0.1496P PS=1.7U
+ PD=1.12U
* device instance $3 r0 *1 1.335,0.23 pfet_03v3
M$3 Q QB VSS VSS pfet_03v3 L=0.28U W=0.44U AS=0.1496P AD=0.1804P PS=1.12U
+ PD=1.7U
* device instance $4 r0 *1 1.595,2.145 nfet_03v3
M$4 RBL QB VSS$1 VSS$1 nfet_03v3 L=0.28U W=0.22U AS=0.1498P AD=0.1498P PS=1.63U
+ PD=1.63U
* device instance $5 r0 *1 0.07,2.145 nfet_03v3
M$5 A Q RBL VSS$1 nfet_03v3 L=0.28U W=0.22U AS=0.1498P AD=0.148P PS=1.63U
+ PD=1.62U
* device instance $6 r0 *1 -0.025,-1.885 nfet_03v3
M$6 QB WL WBLB VSS$1 nfet_03v3 L=0.28U W=0.32U AS=0.1312P AD=0.1286P PS=1.46U
+ PD=1.155U
* device instance $7 r0 *1 1.735,-1.885 nfet_03v3
M$7 Q WL WBL VSS$1 nfet_03v3 L=0.28U W=0.32U AS=0.1312P AD=0.1286P PS=1.46U
+ PD=1.155U
* device instance $8 r0 *1 0.375,-1.17 nfet_03v3
M$8 VSS$1 Q QB VSS$1 nfet_03v3 L=0.28U W=0.22U AS=0.1286P AD=0.1058P PS=1.155U
+ PD=1.1U
* device instance $9 r0 *1 1.335,-1.17 nfet_03v3
M$9 VSS$1 QB Q VSS$1 nfet_03v3 L=0.28U W=0.22U AS=0.1286P AD=0.1058P PS=1.155U
+ PD=1.1U
.ENDS 9T_pfet_on_top
