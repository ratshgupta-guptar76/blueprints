* SPICE3 file created from 9T_pfet_on_top.ext - technology: gf180mcuD

.option scale=5n

X0 QB WL WBLB VSS nfet_03v3 ad=5.144n pd=0.231m as=5.248n ps=0.292m w=64 l=56
X1 Q QB VDD VDD pfet_03v3 ad=7.216n pd=0.34m as=5.984n ps=0.224m w=88 l=56
X2 RBL Q A VSS nfet_03v3 ad=5.992n pd=0.326m as=5.92n ps=0.324m w=44 l=56
X3 RBL QB VSS VSS nfet_03v3 ad=5.992n pd=0.326m as=5.992n ps=0.326m w=44 l=56
X4 Q WL WBL VSS nfet_03v3 ad=5.144n pd=0.231m as=5.248n ps=0.292m w=64 l=56
X5 Q QB VSS VSS nfet_03v3 ad=5.144n pd=0.231m as=4.232n ps=0.22m w=44 l=56
X6 RBL QB A VDD pfet_03v3 ad=8.096n pd=0.36m as=8.096n ps=0.36m w=88 l=56
X7 VDD Q QB VDD pfet_03v3 ad=5.984n pd=0.224m as=7.216n ps=0.34m w=88 l=56
X8 VSS Q QB VSS nfet_03v3 ad=4.232n pd=0.22m as=5.144n ps=0.231m w=44 l=56
C0 A VDD 0.18356f
C1 WBL VDD 0
C2 QB Q 0.433f
C3 A Q 0.05486f
C4 Q WBL 0.02266f
C5 Q VDD 0.38486f
C6 RBL WL 0
C7 WL WBLB 0.00409f
C8 QB RBL 0.04391f
C9 QB WL 0.02607f
C10 QB WBLB 0.02424f
C11 A RBL 0.31109f
C12 A WL 0.00332f
C13 RBL WBL 0
C14 WL WBL 0.0041f
C15 RBL VDD 0.05146f
C16 WL VDD 0.01243f
C17 A WBLB 0
C18 WBLB VDD 0
C19 QB A 0.04448f
C20 QB WBL 0
C21 QB VDD 0.20925f
C22 Q RBL 0.06704f
C23 Q WL 0.02082f
C24 Q WBLB 0
C25 WBL VSS 0.17374f
C26 WBLB VSS 0.08171f
C27 WL VSS 0.40872f
C28 QB VSS 0.48954f
C29 RBL VSS 0.41445f
C30 Q VSS 0.40768f
C31 A VSS 0.09733f
C32 VDD VSS 1.35615f
