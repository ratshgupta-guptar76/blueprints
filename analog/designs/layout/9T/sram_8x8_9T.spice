* NGSPICE file created from sram_8x8_9T.ext - technology: gf180mcuD

.subckt x9T_tileable WL A RBL VDD VSS WBLB WBL a_199_412# a_103_8# VSUBS
X0 RBL a_n45_n270# a_199_412# VSUBS nfet_03v3 ad=0.1516p pd=1.64u as=0.1516p ps=1.64u w=0.22u l=0.28u
X1 a_n45_n270# WL WBLB VSUBS nfet_03v3 ad=0.139p pd=1.215u as=0.2362p ps=2.03u w=0.32u l=0.28u
X2 a_n14_236# a_n45_n270# a_103_8# VDD pfet_03v3 ad=0.1936p pd=1.76u as=0.1496p ps=1.12u w=0.44u l=0.28u
X3 a_n14_236# WL WBL VSUBS nfet_03v3 ad=0.1397p pd=1.22u as=0.1706p ps=1.7u w=0.32u l=0.28u
X4 a_n14_236# a_n45_n270# VSS VSUBS nfet_03v3 ad=0.1397p pd=1.22u as=0.1108p ps=1.1u w=0.22u l=0.28u
X5 a_103_8# a_n14_236# a_n45_n270# VDD pfet_03v3 ad=0.1496p pd=1.12u as=0.1936p ps=1.76u w=0.44u l=0.28u
X6 RBL a_n14_236# A VSUBS nfet_03v3 ad=0.1516p pd=1.64u as=0.1516p ps=1.64u w=0.22u l=0.28u
X7 VSS a_n14_236# a_n45_n270# VSUBS nfet_03v3 ad=0.1108p pd=1.1u as=0.139p ps=1.215u w=0.22u l=0.28u
X8 RBL a_n45_n270# A VDD pfet_03v3 ad=0.2082p pd=1.84u as=0.2024p ps=1.8u w=0.44u l=0.28u
.ends

.subckt sram_8x8_9T RBL[24] RBL[16] RBL[8] RBL[0] RBL[25] RBL[17] RBL[9] RBL[1] RBL[26]
+ RBL[18] RBL[10] RBL[2] RBL[27] RBL[19] RBL[11] RBL[3] RBL[28] RBL[20] RBL[12] RBL[4]
+ RBL[29] RBL[21] RBL[13] RBL[5] RBL[30] RBL[22] RBL[14] RBL[6] RBL[31] RBL[23] RBL[15]
+ RBL[7]
X9T_tileable_0[0|0] 9T_tileable_0[0|7]/WL 9T_tileable_0[0|7]/A RBL[0] 9T_tileable_0[0|7]/VDD
+ 9T_tileable_0[7|7]/VSS 9T_tileable_0[7|0]/WBLB 9T_tileable_0[7|0]/WBL 9T_tileable_0[7|7]/VSS
+ 9T_tileable_0[0|7]/VDD 9T_tileable_0[7|7]/VSS x9T_tileable
X9T_tileable_0[1|0] 9T_tileable_0[1|7]/WL 9T_tileable_0[1|7]/A RBL[8] 9T_tileable_0[1|7]/VDD
+ 9T_tileable_0[7|7]/VSS 9T_tileable_0[7|0]/WBLB 9T_tileable_0[7|0]/WBL 9T_tileable_0[7|7]/VSS
+ 9T_tileable_0[1|7]/VDD 9T_tileable_0[7|7]/VSS x9T_tileable
X9T_tileable_0[2|0] 9T_tileable_0[2|7]/WL 9T_tileable_0[2|7]/A RBL[16] 9T_tileable_0[2|7]/VDD
+ 9T_tileable_0[7|7]/VSS 9T_tileable_0[7|0]/WBLB 9T_tileable_0[7|0]/WBL 9T_tileable_0[7|7]/VSS
+ 9T_tileable_0[2|7]/VDD 9T_tileable_0[7|7]/VSS x9T_tileable
X9T_tileable_0[3|0] 9T_tileable_0[3|7]/WL 9T_tileable_0[3|7]/A RBL[24] 9T_tileable_0[3|7]/VDD
+ 9T_tileable_0[7|7]/VSS 9T_tileable_0[7|0]/WBLB 9T_tileable_0[7|0]/WBL 9T_tileable_0[7|7]/VSS
+ 9T_tileable_0[3|7]/VDD 9T_tileable_0[7|7]/VSS x9T_tileable
X9T_tileable_0[4|0] 9T_tileable_0[4|7]/WL 9T_tileable_0[4|7]/A 9T_tileable_0[4|0]/RBL
+ 9T_tileable_0[4|7]/VDD 9T_tileable_0[7|7]/VSS 9T_tileable_0[7|0]/WBLB 9T_tileable_0[7|0]/WBL
+ 9T_tileable_0[7|7]/VSS 9T_tileable_0[4|7]/VDD 9T_tileable_0[7|7]/VSS x9T_tileable
X9T_tileable_0[5|0] 9T_tileable_0[5|7]/WL 9T_tileable_0[5|7]/A 9T_tileable_0[5|0]/RBL
+ 9T_tileable_0[5|7]/VDD 9T_tileable_0[7|7]/VSS 9T_tileable_0[7|0]/WBLB 9T_tileable_0[7|0]/WBL
+ 9T_tileable_0[7|7]/VSS 9T_tileable_0[5|7]/VDD 9T_tileable_0[7|7]/VSS x9T_tileable
X9T_tileable_0[6|0] 9T_tileable_0[6|7]/WL 9T_tileable_0[6|7]/A 9T_tileable_0[6|0]/RBL
+ 9T_tileable_0[6|7]/VDD 9T_tileable_0[7|7]/VSS 9T_tileable_0[7|0]/WBLB 9T_tileable_0[7|0]/WBL
+ 9T_tileable_0[7|7]/VSS 9T_tileable_0[6|7]/VDD 9T_tileable_0[7|7]/VSS x9T_tileable
X9T_tileable_0[7|0] 9T_tileable_0[7|7]/WL 9T_tileable_0[7|7]/A 9T_tileable_0[7|0]/RBL
+ 9T_tileable_0[7|7]/VDD 9T_tileable_0[7|7]/VSS 9T_tileable_0[7|0]/WBLB 9T_tileable_0[7|0]/WBL
+ 9T_tileable_0[7|0]/a_199_412# 9T_tileable_0[7|7]/VDD 9T_tileable_0[7|7]/VSS x9T_tileable
X9T_tileable_0[0|1] 9T_tileable_0[0|7]/WL 9T_tileable_0[0|7]/A RBL[1] 9T_tileable_0[0|7]/VDD
+ 9T_tileable_0[7|7]/VSS 9T_tileable_0[7|1]/WBLB 9T_tileable_0[7|1]/WBL 9T_tileable_0[7|7]/VSS
+ 9T_tileable_0[0|7]/VDD 9T_tileable_0[7|7]/VSS x9T_tileable
X9T_tileable_0[1|1] 9T_tileable_0[1|7]/WL 9T_tileable_0[1|7]/A RBL[9] 9T_tileable_0[1|7]/VDD
+ 9T_tileable_0[7|7]/VSS 9T_tileable_0[7|1]/WBLB 9T_tileable_0[7|1]/WBL 9T_tileable_0[7|7]/VSS
+ 9T_tileable_0[1|7]/VDD 9T_tileable_0[7|7]/VSS x9T_tileable
X9T_tileable_0[2|1] 9T_tileable_0[2|7]/WL 9T_tileable_0[2|7]/A RBL[17] 9T_tileable_0[2|7]/VDD
+ 9T_tileable_0[7|7]/VSS 9T_tileable_0[7|1]/WBLB 9T_tileable_0[7|1]/WBL 9T_tileable_0[7|7]/VSS
+ 9T_tileable_0[2|7]/VDD 9T_tileable_0[7|7]/VSS x9T_tileable
X9T_tileable_0[3|1] 9T_tileable_0[3|7]/WL 9T_tileable_0[3|7]/A RBL[25] 9T_tileable_0[3|7]/VDD
+ 9T_tileable_0[7|7]/VSS 9T_tileable_0[7|1]/WBLB 9T_tileable_0[7|1]/WBL 9T_tileable_0[7|7]/VSS
+ 9T_tileable_0[3|7]/VDD 9T_tileable_0[7|7]/VSS x9T_tileable
X9T_tileable_0[4|1] 9T_tileable_0[4|7]/WL 9T_tileable_0[4|7]/A 9T_tileable_0[4|1]/RBL
+ 9T_tileable_0[4|7]/VDD 9T_tileable_0[7|7]/VSS 9T_tileable_0[7|1]/WBLB 9T_tileable_0[7|1]/WBL
+ 9T_tileable_0[7|7]/VSS 9T_tileable_0[4|7]/VDD 9T_tileable_0[7|7]/VSS x9T_tileable
X9T_tileable_0[5|1] 9T_tileable_0[5|7]/WL 9T_tileable_0[5|7]/A 9T_tileable_0[5|1]/RBL
+ 9T_tileable_0[5|7]/VDD 9T_tileable_0[7|7]/VSS 9T_tileable_0[7|1]/WBLB 9T_tileable_0[7|1]/WBL
+ 9T_tileable_0[7|7]/VSS 9T_tileable_0[5|7]/VDD 9T_tileable_0[7|7]/VSS x9T_tileable
X9T_tileable_0[6|1] 9T_tileable_0[6|7]/WL 9T_tileable_0[6|7]/A 9T_tileable_0[6|1]/RBL
+ 9T_tileable_0[6|7]/VDD 9T_tileable_0[7|7]/VSS 9T_tileable_0[7|1]/WBLB 9T_tileable_0[7|1]/WBL
+ 9T_tileable_0[7|7]/VSS 9T_tileable_0[6|7]/VDD 9T_tileable_0[7|7]/VSS x9T_tileable
X9T_tileable_0[7|1] 9T_tileable_0[7|7]/WL 9T_tileable_0[7|7]/A 9T_tileable_0[7|1]/RBL
+ 9T_tileable_0[7|7]/VDD 9T_tileable_0[7|7]/VSS 9T_tileable_0[7|1]/WBLB 9T_tileable_0[7|1]/WBL
+ 9T_tileable_0[7|1]/a_199_412# 9T_tileable_0[7|7]/VDD 9T_tileable_0[7|7]/VSS x9T_tileable
X9T_tileable_0[0|2] 9T_tileable_0[0|7]/WL 9T_tileable_0[0|7]/A RBL[2] 9T_tileable_0[0|7]/VDD
+ 9T_tileable_0[7|7]/VSS 9T_tileable_0[7|2]/WBLB 9T_tileable_0[7|2]/WBL 9T_tileable_0[7|7]/VSS
+ 9T_tileable_0[0|7]/VDD 9T_tileable_0[7|7]/VSS x9T_tileable
X9T_tileable_0[1|2] 9T_tileable_0[1|7]/WL 9T_tileable_0[1|7]/A RBL[10] 9T_tileable_0[1|7]/VDD
+ 9T_tileable_0[7|7]/VSS 9T_tileable_0[7|2]/WBLB 9T_tileable_0[7|2]/WBL 9T_tileable_0[7|7]/VSS
+ 9T_tileable_0[1|7]/VDD 9T_tileable_0[7|7]/VSS x9T_tileable
X9T_tileable_0[2|2] 9T_tileable_0[2|7]/WL 9T_tileable_0[2|7]/A RBL[18] 9T_tileable_0[2|7]/VDD
+ 9T_tileable_0[7|7]/VSS 9T_tileable_0[7|2]/WBLB 9T_tileable_0[7|2]/WBL 9T_tileable_0[7|7]/VSS
+ 9T_tileable_0[2|7]/VDD 9T_tileable_0[7|7]/VSS x9T_tileable
X9T_tileable_0[3|2] 9T_tileable_0[3|7]/WL 9T_tileable_0[3|7]/A RBL[26] 9T_tileable_0[3|7]/VDD
+ 9T_tileable_0[7|7]/VSS 9T_tileable_0[7|2]/WBLB 9T_tileable_0[7|2]/WBL 9T_tileable_0[7|7]/VSS
+ 9T_tileable_0[3|7]/VDD 9T_tileable_0[7|7]/VSS x9T_tileable
X9T_tileable_0[4|2] 9T_tileable_0[4|7]/WL 9T_tileable_0[4|7]/A 9T_tileable_0[4|2]/RBL
+ 9T_tileable_0[4|7]/VDD 9T_tileable_0[7|7]/VSS 9T_tileable_0[7|2]/WBLB 9T_tileable_0[7|2]/WBL
+ 9T_tileable_0[7|7]/VSS 9T_tileable_0[4|7]/VDD 9T_tileable_0[7|7]/VSS x9T_tileable
X9T_tileable_0[5|2] 9T_tileable_0[5|7]/WL 9T_tileable_0[5|7]/A 9T_tileable_0[5|2]/RBL
+ 9T_tileable_0[5|7]/VDD 9T_tileable_0[7|7]/VSS 9T_tileable_0[7|2]/WBLB 9T_tileable_0[7|2]/WBL
+ 9T_tileable_0[7|7]/VSS 9T_tileable_0[5|7]/VDD 9T_tileable_0[7|7]/VSS x9T_tileable
X9T_tileable_0[6|2] 9T_tileable_0[6|7]/WL 9T_tileable_0[6|7]/A 9T_tileable_0[6|2]/RBL
+ 9T_tileable_0[6|7]/VDD 9T_tileable_0[7|7]/VSS 9T_tileable_0[7|2]/WBLB 9T_tileable_0[7|2]/WBL
+ 9T_tileable_0[7|7]/VSS 9T_tileable_0[6|7]/VDD 9T_tileable_0[7|7]/VSS x9T_tileable
X9T_tileable_0[7|2] 9T_tileable_0[7|7]/WL 9T_tileable_0[7|7]/A 9T_tileable_0[7|2]/RBL
+ 9T_tileable_0[7|7]/VDD 9T_tileable_0[7|7]/VSS 9T_tileable_0[7|2]/WBLB 9T_tileable_0[7|2]/WBL
+ 9T_tileable_0[7|2]/a_199_412# 9T_tileable_0[7|7]/VDD 9T_tileable_0[7|7]/VSS x9T_tileable
X9T_tileable_0[0|3] 9T_tileable_0[0|7]/WL 9T_tileable_0[0|7]/A RBL[3] 9T_tileable_0[0|7]/VDD
+ 9T_tileable_0[7|7]/VSS 9T_tileable_0[7|3]/WBLB 9T_tileable_0[7|3]/WBL 9T_tileable_0[7|7]/VSS
+ 9T_tileable_0[0|7]/VDD 9T_tileable_0[7|7]/VSS x9T_tileable
X9T_tileable_0[1|3] 9T_tileable_0[1|7]/WL 9T_tileable_0[1|7]/A RBL[11] 9T_tileable_0[1|7]/VDD
+ 9T_tileable_0[7|7]/VSS 9T_tileable_0[7|3]/WBLB 9T_tileable_0[7|3]/WBL 9T_tileable_0[7|7]/VSS
+ 9T_tileable_0[1|7]/VDD 9T_tileable_0[7|7]/VSS x9T_tileable
X9T_tileable_0[2|3] 9T_tileable_0[2|7]/WL 9T_tileable_0[2|7]/A RBL[19] 9T_tileable_0[2|7]/VDD
+ 9T_tileable_0[7|7]/VSS 9T_tileable_0[7|3]/WBLB 9T_tileable_0[7|3]/WBL 9T_tileable_0[7|7]/VSS
+ 9T_tileable_0[2|7]/VDD 9T_tileable_0[7|7]/VSS x9T_tileable
X9T_tileable_0[3|3] 9T_tileable_0[3|7]/WL 9T_tileable_0[3|7]/A RBL[27] 9T_tileable_0[3|7]/VDD
+ 9T_tileable_0[7|7]/VSS 9T_tileable_0[7|3]/WBLB 9T_tileable_0[7|3]/WBL 9T_tileable_0[7|7]/VSS
+ 9T_tileable_0[3|7]/VDD 9T_tileable_0[7|7]/VSS x9T_tileable
X9T_tileable_0[4|3] 9T_tileable_0[4|7]/WL 9T_tileable_0[4|7]/A 9T_tileable_0[4|3]/RBL
+ 9T_tileable_0[4|7]/VDD 9T_tileable_0[7|7]/VSS 9T_tileable_0[7|3]/WBLB 9T_tileable_0[7|3]/WBL
+ 9T_tileable_0[7|7]/VSS 9T_tileable_0[4|7]/VDD 9T_tileable_0[7|7]/VSS x9T_tileable
X9T_tileable_0[5|3] 9T_tileable_0[5|7]/WL 9T_tileable_0[5|7]/A 9T_tileable_0[5|3]/RBL
+ 9T_tileable_0[5|7]/VDD 9T_tileable_0[7|7]/VSS 9T_tileable_0[7|3]/WBLB 9T_tileable_0[7|3]/WBL
+ 9T_tileable_0[7|7]/VSS 9T_tileable_0[5|7]/VDD 9T_tileable_0[7|7]/VSS x9T_tileable
X9T_tileable_0[6|3] 9T_tileable_0[6|7]/WL 9T_tileable_0[6|7]/A 9T_tileable_0[6|3]/RBL
+ 9T_tileable_0[6|7]/VDD 9T_tileable_0[7|7]/VSS 9T_tileable_0[7|3]/WBLB 9T_tileable_0[7|3]/WBL
+ 9T_tileable_0[7|7]/VSS 9T_tileable_0[6|7]/VDD 9T_tileable_0[7|7]/VSS x9T_tileable
X9T_tileable_0[7|3] 9T_tileable_0[7|7]/WL 9T_tileable_0[7|7]/A 9T_tileable_0[7|3]/RBL
+ 9T_tileable_0[7|7]/VDD 9T_tileable_0[7|7]/VSS 9T_tileable_0[7|3]/WBLB 9T_tileable_0[7|3]/WBL
+ 9T_tileable_0[7|3]/a_199_412# 9T_tileable_0[7|7]/VDD 9T_tileable_0[7|7]/VSS x9T_tileable
X9T_tileable_0[0|4] 9T_tileable_0[0|7]/WL 9T_tileable_0[0|7]/A RBL[4] 9T_tileable_0[0|7]/VDD
+ 9T_tileable_0[7|7]/VSS 9T_tileable_0[7|4]/WBLB 9T_tileable_0[7|4]/WBL 9T_tileable_0[7|7]/VSS
+ 9T_tileable_0[0|7]/VDD 9T_tileable_0[7|7]/VSS x9T_tileable
X9T_tileable_0[1|4] 9T_tileable_0[1|7]/WL 9T_tileable_0[1|7]/A RBL[12] 9T_tileable_0[1|7]/VDD
+ 9T_tileable_0[7|7]/VSS 9T_tileable_0[7|4]/WBLB 9T_tileable_0[7|4]/WBL 9T_tileable_0[7|7]/VSS
+ 9T_tileable_0[1|7]/VDD 9T_tileable_0[7|7]/VSS x9T_tileable
X9T_tileable_0[2|4] 9T_tileable_0[2|7]/WL 9T_tileable_0[2|7]/A RBL[20] 9T_tileable_0[2|7]/VDD
+ 9T_tileable_0[7|7]/VSS 9T_tileable_0[7|4]/WBLB 9T_tileable_0[7|4]/WBL 9T_tileable_0[7|7]/VSS
+ 9T_tileable_0[2|7]/VDD 9T_tileable_0[7|7]/VSS x9T_tileable
X9T_tileable_0[3|4] 9T_tileable_0[3|7]/WL 9T_tileable_0[3|7]/A RBL[28] 9T_tileable_0[3|7]/VDD
+ 9T_tileable_0[7|7]/VSS 9T_tileable_0[7|4]/WBLB 9T_tileable_0[7|4]/WBL 9T_tileable_0[7|7]/VSS
+ 9T_tileable_0[3|7]/VDD 9T_tileable_0[7|7]/VSS x9T_tileable
X9T_tileable_0[4|4] 9T_tileable_0[4|7]/WL 9T_tileable_0[4|7]/A 9T_tileable_0[4|4]/RBL
+ 9T_tileable_0[4|7]/VDD 9T_tileable_0[7|7]/VSS 9T_tileable_0[7|4]/WBLB 9T_tileable_0[7|4]/WBL
+ 9T_tileable_0[7|7]/VSS 9T_tileable_0[4|7]/VDD 9T_tileable_0[7|7]/VSS x9T_tileable
X9T_tileable_0[5|4] 9T_tileable_0[5|7]/WL 9T_tileable_0[5|7]/A 9T_tileable_0[5|4]/RBL
+ 9T_tileable_0[5|7]/VDD 9T_tileable_0[7|7]/VSS 9T_tileable_0[7|4]/WBLB 9T_tileable_0[7|4]/WBL
+ 9T_tileable_0[7|7]/VSS 9T_tileable_0[5|7]/VDD 9T_tileable_0[7|7]/VSS x9T_tileable
X9T_tileable_0[6|4] 9T_tileable_0[6|7]/WL 9T_tileable_0[6|7]/A 9T_tileable_0[6|4]/RBL
+ 9T_tileable_0[6|7]/VDD 9T_tileable_0[7|7]/VSS 9T_tileable_0[7|4]/WBLB 9T_tileable_0[7|4]/WBL
+ 9T_tileable_0[7|7]/VSS 9T_tileable_0[6|7]/VDD 9T_tileable_0[7|7]/VSS x9T_tileable
X9T_tileable_0[7|4] 9T_tileable_0[7|7]/WL 9T_tileable_0[7|7]/A 9T_tileable_0[7|4]/RBL
+ 9T_tileable_0[7|7]/VDD 9T_tileable_0[7|7]/VSS 9T_tileable_0[7|4]/WBLB 9T_tileable_0[7|4]/WBL
+ 9T_tileable_0[7|4]/a_199_412# 9T_tileable_0[7|7]/VDD 9T_tileable_0[7|7]/VSS x9T_tileable
X9T_tileable_0[0|5] 9T_tileable_0[0|7]/WL 9T_tileable_0[0|7]/A RBL[5] 9T_tileable_0[0|7]/VDD
+ 9T_tileable_0[7|7]/VSS 9T_tileable_0[7|5]/WBLB 9T_tileable_0[7|5]/WBL 9T_tileable_0[7|7]/VSS
+ 9T_tileable_0[0|7]/VDD 9T_tileable_0[7|7]/VSS x9T_tileable
X9T_tileable_0[1|5] 9T_tileable_0[1|7]/WL 9T_tileable_0[1|7]/A RBL[13] 9T_tileable_0[1|7]/VDD
+ 9T_tileable_0[7|7]/VSS 9T_tileable_0[7|5]/WBLB 9T_tileable_0[7|5]/WBL 9T_tileable_0[7|7]/VSS
+ 9T_tileable_0[1|7]/VDD 9T_tileable_0[7|7]/VSS x9T_tileable
X9T_tileable_0[2|5] 9T_tileable_0[2|7]/WL 9T_tileable_0[2|7]/A RBL[21] 9T_tileable_0[2|7]/VDD
+ 9T_tileable_0[7|7]/VSS 9T_tileable_0[7|5]/WBLB 9T_tileable_0[7|5]/WBL 9T_tileable_0[7|7]/VSS
+ 9T_tileable_0[2|7]/VDD 9T_tileable_0[7|7]/VSS x9T_tileable
X9T_tileable_0[3|5] 9T_tileable_0[3|7]/WL 9T_tileable_0[3|7]/A RBL[29] 9T_tileable_0[3|7]/VDD
+ 9T_tileable_0[7|7]/VSS 9T_tileable_0[7|5]/WBLB 9T_tileable_0[7|5]/WBL 9T_tileable_0[7|7]/VSS
+ 9T_tileable_0[3|7]/VDD 9T_tileable_0[7|7]/VSS x9T_tileable
X9T_tileable_0[4|5] 9T_tileable_0[4|7]/WL 9T_tileable_0[4|7]/A 9T_tileable_0[4|5]/RBL
+ 9T_tileable_0[4|7]/VDD 9T_tileable_0[7|7]/VSS 9T_tileable_0[7|5]/WBLB 9T_tileable_0[7|5]/WBL
+ 9T_tileable_0[7|7]/VSS 9T_tileable_0[4|7]/VDD 9T_tileable_0[7|7]/VSS x9T_tileable
X9T_tileable_0[5|5] 9T_tileable_0[5|7]/WL 9T_tileable_0[5|7]/A 9T_tileable_0[5|5]/RBL
+ 9T_tileable_0[5|7]/VDD 9T_tileable_0[7|7]/VSS 9T_tileable_0[7|5]/WBLB 9T_tileable_0[7|5]/WBL
+ 9T_tileable_0[7|7]/VSS 9T_tileable_0[5|7]/VDD 9T_tileable_0[7|7]/VSS x9T_tileable
X9T_tileable_0[6|5] 9T_tileable_0[6|7]/WL 9T_tileable_0[6|7]/A 9T_tileable_0[6|5]/RBL
+ 9T_tileable_0[6|7]/VDD 9T_tileable_0[7|7]/VSS 9T_tileable_0[7|5]/WBLB 9T_tileable_0[7|5]/WBL
+ 9T_tileable_0[7|7]/VSS 9T_tileable_0[6|7]/VDD 9T_tileable_0[7|7]/VSS x9T_tileable
X9T_tileable_0[7|5] 9T_tileable_0[7|7]/WL 9T_tileable_0[7|7]/A 9T_tileable_0[7|5]/RBL
+ 9T_tileable_0[7|7]/VDD 9T_tileable_0[7|7]/VSS 9T_tileable_0[7|5]/WBLB 9T_tileable_0[7|5]/WBL
+ 9T_tileable_0[7|5]/a_199_412# 9T_tileable_0[7|7]/VDD 9T_tileable_0[7|7]/VSS x9T_tileable
X9T_tileable_0[0|6] 9T_tileable_0[0|7]/WL 9T_tileable_0[0|7]/A RBL[6] 9T_tileable_0[0|7]/VDD
+ 9T_tileable_0[7|7]/VSS 9T_tileable_0[7|6]/WBLB 9T_tileable_0[7|6]/WBL 9T_tileable_0[7|7]/VSS
+ 9T_tileable_0[0|7]/VDD 9T_tileable_0[7|7]/VSS x9T_tileable
X9T_tileable_0[1|6] 9T_tileable_0[1|7]/WL 9T_tileable_0[1|7]/A RBL[14] 9T_tileable_0[1|7]/VDD
+ 9T_tileable_0[7|7]/VSS 9T_tileable_0[7|6]/WBLB 9T_tileable_0[7|6]/WBL 9T_tileable_0[7|7]/VSS
+ 9T_tileable_0[1|7]/VDD 9T_tileable_0[7|7]/VSS x9T_tileable
X9T_tileable_0[2|6] 9T_tileable_0[2|7]/WL 9T_tileable_0[2|7]/A RBL[22] 9T_tileable_0[2|7]/VDD
+ 9T_tileable_0[7|7]/VSS 9T_tileable_0[7|6]/WBLB 9T_tileable_0[7|6]/WBL 9T_tileable_0[7|7]/VSS
+ 9T_tileable_0[2|7]/VDD 9T_tileable_0[7|7]/VSS x9T_tileable
X9T_tileable_0[3|6] 9T_tileable_0[3|7]/WL 9T_tileable_0[3|7]/A RBL[30] 9T_tileable_0[3|7]/VDD
+ 9T_tileable_0[7|7]/VSS 9T_tileable_0[7|6]/WBLB 9T_tileable_0[7|6]/WBL 9T_tileable_0[7|7]/VSS
+ 9T_tileable_0[3|7]/VDD 9T_tileable_0[7|7]/VSS x9T_tileable
X9T_tileable_0[4|6] 9T_tileable_0[4|7]/WL 9T_tileable_0[4|7]/A 9T_tileable_0[4|6]/RBL
+ 9T_tileable_0[4|7]/VDD 9T_tileable_0[7|7]/VSS 9T_tileable_0[7|6]/WBLB 9T_tileable_0[7|6]/WBL
+ 9T_tileable_0[7|7]/VSS 9T_tileable_0[4|7]/VDD 9T_tileable_0[7|7]/VSS x9T_tileable
X9T_tileable_0[5|6] 9T_tileable_0[5|7]/WL 9T_tileable_0[5|7]/A 9T_tileable_0[5|6]/RBL
+ 9T_tileable_0[5|7]/VDD 9T_tileable_0[7|7]/VSS 9T_tileable_0[7|6]/WBLB 9T_tileable_0[7|6]/WBL
+ 9T_tileable_0[7|7]/VSS 9T_tileable_0[5|7]/VDD 9T_tileable_0[7|7]/VSS x9T_tileable
X9T_tileable_0[6|6] 9T_tileable_0[6|7]/WL 9T_tileable_0[6|7]/A 9T_tileable_0[6|6]/RBL
+ 9T_tileable_0[6|7]/VDD 9T_tileable_0[7|7]/VSS 9T_tileable_0[7|6]/WBLB 9T_tileable_0[7|6]/WBL
+ 9T_tileable_0[7|7]/VSS 9T_tileable_0[6|7]/VDD 9T_tileable_0[7|7]/VSS x9T_tileable
X9T_tileable_0[7|6] 9T_tileable_0[7|7]/WL 9T_tileable_0[7|7]/A 9T_tileable_0[7|6]/RBL
+ 9T_tileable_0[7|7]/VDD 9T_tileable_0[7|7]/VSS 9T_tileable_0[7|6]/WBLB 9T_tileable_0[7|6]/WBL
+ 9T_tileable_0[7|6]/a_199_412# 9T_tileable_0[7|7]/VDD 9T_tileable_0[7|7]/VSS x9T_tileable
X9T_tileable_0[0|7] 9T_tileable_0[0|7]/WL 9T_tileable_0[0|7]/A RBL[7] 9T_tileable_0[0|7]/VDD
+ 9T_tileable_0[7|7]/VSS 9T_tileable_0[7|7]/WBLB 9T_tileable_0[7|7]/WBL 9T_tileable_0[7|7]/VSS
+ 9T_tileable_0[0|7]/VDD 9T_tileable_0[7|7]/VSS x9T_tileable
X9T_tileable_0[1|7] 9T_tileable_0[1|7]/WL 9T_tileable_0[1|7]/A RBL[15] 9T_tileable_0[1|7]/VDD
+ 9T_tileable_0[7|7]/VSS 9T_tileable_0[7|7]/WBLB 9T_tileable_0[7|7]/WBL 9T_tileable_0[7|7]/VSS
+ 9T_tileable_0[1|7]/VDD 9T_tileable_0[7|7]/VSS x9T_tileable
X9T_tileable_0[2|7] 9T_tileable_0[2|7]/WL 9T_tileable_0[2|7]/A RBL[23] 9T_tileable_0[2|7]/VDD
+ 9T_tileable_0[7|7]/VSS 9T_tileable_0[7|7]/WBLB 9T_tileable_0[7|7]/WBL 9T_tileable_0[7|7]/VSS
+ 9T_tileable_0[2|7]/VDD 9T_tileable_0[7|7]/VSS x9T_tileable
X9T_tileable_0[3|7] 9T_tileable_0[3|7]/WL 9T_tileable_0[3|7]/A RBL[31] 9T_tileable_0[3|7]/VDD
+ 9T_tileable_0[7|7]/VSS 9T_tileable_0[7|7]/WBLB 9T_tileable_0[7|7]/WBL 9T_tileable_0[7|7]/VSS
+ 9T_tileable_0[3|7]/VDD 9T_tileable_0[7|7]/VSS x9T_tileable
X9T_tileable_0[4|7] 9T_tileable_0[4|7]/WL 9T_tileable_0[4|7]/A 9T_tileable_0[4|7]/RBL
+ 9T_tileable_0[4|7]/VDD 9T_tileable_0[7|7]/VSS 9T_tileable_0[7|7]/WBLB 9T_tileable_0[7|7]/WBL
+ 9T_tileable_0[7|7]/VSS 9T_tileable_0[4|7]/VDD 9T_tileable_0[7|7]/VSS x9T_tileable
X9T_tileable_0[5|7] 9T_tileable_0[5|7]/WL 9T_tileable_0[5|7]/A 9T_tileable_0[5|7]/RBL
+ 9T_tileable_0[5|7]/VDD 9T_tileable_0[7|7]/VSS 9T_tileable_0[7|7]/WBLB 9T_tileable_0[7|7]/WBL
+ 9T_tileable_0[7|7]/VSS 9T_tileable_0[5|7]/VDD 9T_tileable_0[7|7]/VSS x9T_tileable
X9T_tileable_0[6|7] 9T_tileable_0[6|7]/WL 9T_tileable_0[6|7]/A 9T_tileable_0[6|7]/RBL
+ 9T_tileable_0[6|7]/VDD 9T_tileable_0[7|7]/VSS 9T_tileable_0[7|7]/WBLB 9T_tileable_0[7|7]/WBL
+ 9T_tileable_0[7|7]/VSS 9T_tileable_0[6|7]/VDD 9T_tileable_0[7|7]/VSS x9T_tileable
X9T_tileable_0[7|7] 9T_tileable_0[7|7]/WL 9T_tileable_0[7|7]/A 9T_tileable_0[7|7]/RBL
+ 9T_tileable_0[7|7]/VDD 9T_tileable_0[7|7]/VSS 9T_tileable_0[7|7]/WBLB 9T_tileable_0[7|7]/WBL
+ 9T_tileable_0[7|7]/a_199_412# 9T_tileable_0[7|7]/VDD 9T_tileable_0[7|7]/VSS x9T_tileable
.ends
