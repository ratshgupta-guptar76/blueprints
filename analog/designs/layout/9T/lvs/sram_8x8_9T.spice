* NGSPICE file created from sram_8x8_9T.ext - technology: gf180mcuD

.subckt x9T_tileable WBL WBLB WL A RBL VDD VSS a_199_412# a_103_8# VSUBS
X0 RBL QB a_199_412# VSUBS nfet_03v3 ad=0.1516p pd=1.64u as=0.1516p ps=1.64u w=0.22u l=0.28u
X1 QB WL WBL VSUBS nfet_03v3 ad=0.139p pd=1.215u as=0.2362p ps=2.03u w=0.32u l=0.28u
X2 Q QB a_103_8# VDD pfet_03v3 ad=0.1936p pd=1.76u as=0.1496p ps=1.12u w=0.44u l=0.28u
X3 Q WL WBLB VSUBS nfet_03v3 ad=0.1397p pd=1.22u as=0.1706p ps=1.7u w=0.32u l=0.28u
X4 Q QB VSS VSUBS nfet_03v3 ad=0.1397p pd=1.22u as=0.1108p ps=1.1u w=0.22u l=0.28u
X5 a_103_8# Q QB VDD pfet_03v3 ad=0.1496p pd=1.12u as=0.1936p ps=1.76u w=0.44u l=0.28u
X6 RBL Q A VSUBS nfet_03v3 ad=0.1516p pd=1.64u as=0.1516p ps=1.64u w=0.22u l=0.28u
X7 VSS Q QB VSUBS nfet_03v3 ad=0.1108p pd=1.1u as=0.139p ps=1.215u w=0.22u l=0.28u
X8 RBL QB A VDD pfet_03v3 ad=0.2082p pd=1.84u as=0.2024p ps=1.8u w=0.44u l=0.28u
.ends

.subckt sram_8x8_9T
X9T_tileable_0[0|0] 9T_tileable_0[7|0]/WBL 9T_tileable_0[7|0]/WBLB 9T_tileable_0[0|7]/WL
+ 9T_tileable_0[0|7]/A 9T_tileable_0[0|0]/RBL 9T_tileable_0[0|7]/VDD 9T_tileable_0[7|7]/VSS
+ 9T_tileable_0[7|7]/VSS 9T_tileable_0[0|7]/VDD 9T_tileable_0[7|7]/VSS x9T_tileable
X9T_tileable_0[1|0] 9T_tileable_0[7|0]/WBL 9T_tileable_0[7|0]/WBLB 9T_tileable_0[1|7]/WL
+ 9T_tileable_0[1|7]/A 9T_tileable_0[1|0]/RBL 9T_tileable_0[1|7]/VDD 9T_tileable_0[7|7]/VSS
+ 9T_tileable_0[7|7]/VSS 9T_tileable_0[1|7]/VDD 9T_tileable_0[7|7]/VSS x9T_tileable
X9T_tileable_0[2|0] 9T_tileable_0[7|0]/WBL 9T_tileable_0[7|0]/WBLB 9T_tileable_0[2|7]/WL
+ 9T_tileable_0[2|7]/A 9T_tileable_0[2|0]/RBL 9T_tileable_0[2|7]/VDD 9T_tileable_0[7|7]/VSS
+ 9T_tileable_0[7|7]/VSS 9T_tileable_0[2|7]/VDD 9T_tileable_0[7|7]/VSS x9T_tileable
X9T_tileable_0[3|0] 9T_tileable_0[7|0]/WBL 9T_tileable_0[7|0]/WBLB 9T_tileable_0[3|7]/WL
+ 9T_tileable_0[3|7]/A 9T_tileable_0[3|0]/RBL 9T_tileable_0[3|7]/VDD 9T_tileable_0[7|7]/VSS
+ 9T_tileable_0[7|7]/VSS 9T_tileable_0[3|7]/VDD 9T_tileable_0[7|7]/VSS x9T_tileable
X9T_tileable_0[4|0] 9T_tileable_0[7|0]/WBL 9T_tileable_0[7|0]/WBLB 9T_tileable_0[4|7]/WL
+ 9T_tileable_0[4|7]/A 9T_tileable_0[4|0]/RBL 9T_tileable_0[4|7]/VDD 9T_tileable_0[7|7]/VSS
+ 9T_tileable_0[7|7]/VSS 9T_tileable_0[4|7]/VDD 9T_tileable_0[7|7]/VSS x9T_tileable
X9T_tileable_0[5|0] 9T_tileable_0[7|0]/WBL 9T_tileable_0[7|0]/WBLB 9T_tileable_0[5|7]/WL
+ 9T_tileable_0[5|7]/A 9T_tileable_0[5|0]/RBL 9T_tileable_0[5|7]/VDD 9T_tileable_0[7|7]/VSS
+ 9T_tileable_0[7|7]/VSS 9T_tileable_0[5|7]/VDD 9T_tileable_0[7|7]/VSS x9T_tileable
X9T_tileable_0[6|0] 9T_tileable_0[7|0]/WBL 9T_tileable_0[7|0]/WBLB 9T_tileable_0[6|7]/WL
+ 9T_tileable_0[6|7]/A 9T_tileable_0[6|0]/RBL 9T_tileable_0[6|7]/VDD 9T_tileable_0[7|7]/VSS
+ 9T_tileable_0[7|7]/VSS 9T_tileable_0[6|7]/VDD 9T_tileable_0[7|7]/VSS x9T_tileable
X9T_tileable_0[7|0] 9T_tileable_0[7|0]/WBL 9T_tileable_0[7|0]/WBLB 9T_tileable_0[7|7]/WL
+ 9T_tileable_0[7|7]/A 9T_tileable_0[7|0]/RBL 9T_tileable_0[7|7]/VDD 9T_tileable_0[7|7]/VSS
+ 9T_tileable_0[7|0]/a_199_412# 9T_tileable_0[7|7]/VDD 9T_tileable_0[7|7]/VSS x9T_tileable
X9T_tileable_0[0|1] 9T_tileable_0[7|1]/WBL 9T_tileable_0[7|1]/WBLB 9T_tileable_0[0|7]/WL
+ 9T_tileable_0[0|7]/A 9T_tileable_0[0|1]/RBL 9T_tileable_0[0|7]/VDD 9T_tileable_0[7|7]/VSS
+ 9T_tileable_0[7|7]/VSS 9T_tileable_0[0|7]/VDD 9T_tileable_0[7|7]/VSS x9T_tileable
X9T_tileable_0[1|1] 9T_tileable_0[7|1]/WBL 9T_tileable_0[7|1]/WBLB 9T_tileable_0[1|7]/WL
+ 9T_tileable_0[1|7]/A 9T_tileable_0[1|1]/RBL 9T_tileable_0[1|7]/VDD 9T_tileable_0[7|7]/VSS
+ 9T_tileable_0[7|7]/VSS 9T_tileable_0[1|7]/VDD 9T_tileable_0[7|7]/VSS x9T_tileable
X9T_tileable_0[2|1] 9T_tileable_0[7|1]/WBL 9T_tileable_0[7|1]/WBLB 9T_tileable_0[2|7]/WL
+ 9T_tileable_0[2|7]/A 9T_tileable_0[2|1]/RBL 9T_tileable_0[2|7]/VDD 9T_tileable_0[7|7]/VSS
+ 9T_tileable_0[7|7]/VSS 9T_tileable_0[2|7]/VDD 9T_tileable_0[7|7]/VSS x9T_tileable
X9T_tileable_0[3|1] 9T_tileable_0[7|1]/WBL 9T_tileable_0[7|1]/WBLB 9T_tileable_0[3|7]/WL
+ 9T_tileable_0[3|7]/A 9T_tileable_0[3|1]/RBL 9T_tileable_0[3|7]/VDD 9T_tileable_0[7|7]/VSS
+ 9T_tileable_0[7|7]/VSS 9T_tileable_0[3|7]/VDD 9T_tileable_0[7|7]/VSS x9T_tileable
X9T_tileable_0[4|1] 9T_tileable_0[7|1]/WBL 9T_tileable_0[7|1]/WBLB 9T_tileable_0[4|7]/WL
+ 9T_tileable_0[4|7]/A 9T_tileable_0[4|1]/RBL 9T_tileable_0[4|7]/VDD 9T_tileable_0[7|7]/VSS
+ 9T_tileable_0[7|7]/VSS 9T_tileable_0[4|7]/VDD 9T_tileable_0[7|7]/VSS x9T_tileable
X9T_tileable_0[5|1] 9T_tileable_0[7|1]/WBL 9T_tileable_0[7|1]/WBLB 9T_tileable_0[5|7]/WL
+ 9T_tileable_0[5|7]/A 9T_tileable_0[5|1]/RBL 9T_tileable_0[5|7]/VDD 9T_tileable_0[7|7]/VSS
+ 9T_tileable_0[7|7]/VSS 9T_tileable_0[5|7]/VDD 9T_tileable_0[7|7]/VSS x9T_tileable
X9T_tileable_0[6|1] 9T_tileable_0[7|1]/WBL 9T_tileable_0[7|1]/WBLB 9T_tileable_0[6|7]/WL
+ 9T_tileable_0[6|7]/A 9T_tileable_0[6|1]/RBL 9T_tileable_0[6|7]/VDD 9T_tileable_0[7|7]/VSS
+ 9T_tileable_0[7|7]/VSS 9T_tileable_0[6|7]/VDD 9T_tileable_0[7|7]/VSS x9T_tileable
X9T_tileable_0[7|1] 9T_tileable_0[7|1]/WBL 9T_tileable_0[7|1]/WBLB 9T_tileable_0[7|7]/WL
+ 9T_tileable_0[7|7]/A 9T_tileable_0[7|1]/RBL 9T_tileable_0[7|7]/VDD 9T_tileable_0[7|7]/VSS
+ 9T_tileable_0[7|1]/a_199_412# 9T_tileable_0[7|7]/VDD 9T_tileable_0[7|7]/VSS x9T_tileable
X9T_tileable_0[0|2] 9T_tileable_0[7|2]/WBL 9T_tileable_0[7|2]/WBLB 9T_tileable_0[0|7]/WL
+ 9T_tileable_0[0|7]/A 9T_tileable_0[0|2]/RBL 9T_tileable_0[0|7]/VDD 9T_tileable_0[7|7]/VSS
+ 9T_tileable_0[7|7]/VSS 9T_tileable_0[0|7]/VDD 9T_tileable_0[7|7]/VSS x9T_tileable
X9T_tileable_0[1|2] 9T_tileable_0[7|2]/WBL 9T_tileable_0[7|2]/WBLB 9T_tileable_0[1|7]/WL
+ 9T_tileable_0[1|7]/A 9T_tileable_0[1|2]/RBL 9T_tileable_0[1|7]/VDD 9T_tileable_0[7|7]/VSS
+ 9T_tileable_0[7|7]/VSS 9T_tileable_0[1|7]/VDD 9T_tileable_0[7|7]/VSS x9T_tileable
X9T_tileable_0[2|2] 9T_tileable_0[7|2]/WBL 9T_tileable_0[7|2]/WBLB 9T_tileable_0[2|7]/WL
+ 9T_tileable_0[2|7]/A 9T_tileable_0[2|2]/RBL 9T_tileable_0[2|7]/VDD 9T_tileable_0[7|7]/VSS
+ 9T_tileable_0[7|7]/VSS 9T_tileable_0[2|7]/VDD 9T_tileable_0[7|7]/VSS x9T_tileable
X9T_tileable_0[3|2] 9T_tileable_0[7|2]/WBL 9T_tileable_0[7|2]/WBLB 9T_tileable_0[3|7]/WL
+ 9T_tileable_0[3|7]/A 9T_tileable_0[3|2]/RBL 9T_tileable_0[3|7]/VDD 9T_tileable_0[7|7]/VSS
+ 9T_tileable_0[7|7]/VSS 9T_tileable_0[3|7]/VDD 9T_tileable_0[7|7]/VSS x9T_tileable
X9T_tileable_0[4|2] 9T_tileable_0[7|2]/WBL 9T_tileable_0[7|2]/WBLB 9T_tileable_0[4|7]/WL
+ 9T_tileable_0[4|7]/A 9T_tileable_0[4|2]/RBL 9T_tileable_0[4|7]/VDD 9T_tileable_0[7|7]/VSS
+ 9T_tileable_0[7|7]/VSS 9T_tileable_0[4|7]/VDD 9T_tileable_0[7|7]/VSS x9T_tileable
X9T_tileable_0[5|2] 9T_tileable_0[7|2]/WBL 9T_tileable_0[7|2]/WBLB 9T_tileable_0[5|7]/WL
+ 9T_tileable_0[5|7]/A 9T_tileable_0[5|2]/RBL 9T_tileable_0[5|7]/VDD 9T_tileable_0[7|7]/VSS
+ 9T_tileable_0[7|7]/VSS 9T_tileable_0[5|7]/VDD 9T_tileable_0[7|7]/VSS x9T_tileable
X9T_tileable_0[6|2] 9T_tileable_0[7|2]/WBL 9T_tileable_0[7|2]/WBLB 9T_tileable_0[6|7]/WL
+ 9T_tileable_0[6|7]/A 9T_tileable_0[6|2]/RBL 9T_tileable_0[6|7]/VDD 9T_tileable_0[7|7]/VSS
+ 9T_tileable_0[7|7]/VSS 9T_tileable_0[6|7]/VDD 9T_tileable_0[7|7]/VSS x9T_tileable
X9T_tileable_0[7|2] 9T_tileable_0[7|2]/WBL 9T_tileable_0[7|2]/WBLB 9T_tileable_0[7|7]/WL
+ 9T_tileable_0[7|7]/A 9T_tileable_0[7|2]/RBL 9T_tileable_0[7|7]/VDD 9T_tileable_0[7|7]/VSS
+ 9T_tileable_0[7|2]/a_199_412# 9T_tileable_0[7|7]/VDD 9T_tileable_0[7|7]/VSS x9T_tileable
X9T_tileable_0[0|3] 9T_tileable_0[7|3]/WBL 9T_tileable_0[7|3]/WBLB 9T_tileable_0[0|7]/WL
+ 9T_tileable_0[0|7]/A 9T_tileable_0[0|3]/RBL 9T_tileable_0[0|7]/VDD 9T_tileable_0[7|7]/VSS
+ 9T_tileable_0[7|7]/VSS 9T_tileable_0[0|7]/VDD 9T_tileable_0[7|7]/VSS x9T_tileable
X9T_tileable_0[1|3] 9T_tileable_0[7|3]/WBL 9T_tileable_0[7|3]/WBLB 9T_tileable_0[1|7]/WL
+ 9T_tileable_0[1|7]/A 9T_tileable_0[1|3]/RBL 9T_tileable_0[1|7]/VDD 9T_tileable_0[7|7]/VSS
+ 9T_tileable_0[7|7]/VSS 9T_tileable_0[1|7]/VDD 9T_tileable_0[7|7]/VSS x9T_tileable
X9T_tileable_0[2|3] 9T_tileable_0[7|3]/WBL 9T_tileable_0[7|3]/WBLB 9T_tileable_0[2|7]/WL
+ 9T_tileable_0[2|7]/A 9T_tileable_0[2|3]/RBL 9T_tileable_0[2|7]/VDD 9T_tileable_0[7|7]/VSS
+ 9T_tileable_0[7|7]/VSS 9T_tileable_0[2|7]/VDD 9T_tileable_0[7|7]/VSS x9T_tileable
X9T_tileable_0[3|3] 9T_tileable_0[7|3]/WBL 9T_tileable_0[7|3]/WBLB 9T_tileable_0[3|7]/WL
+ 9T_tileable_0[3|7]/A 9T_tileable_0[3|3]/RBL 9T_tileable_0[3|7]/VDD 9T_tileable_0[7|7]/VSS
+ 9T_tileable_0[7|7]/VSS 9T_tileable_0[3|7]/VDD 9T_tileable_0[7|7]/VSS x9T_tileable
X9T_tileable_0[4|3] 9T_tileable_0[7|3]/WBL 9T_tileable_0[7|3]/WBLB 9T_tileable_0[4|7]/WL
+ 9T_tileable_0[4|7]/A 9T_tileable_0[4|3]/RBL 9T_tileable_0[4|7]/VDD 9T_tileable_0[7|7]/VSS
+ 9T_tileable_0[7|7]/VSS 9T_tileable_0[4|7]/VDD 9T_tileable_0[7|7]/VSS x9T_tileable
X9T_tileable_0[5|3] 9T_tileable_0[7|3]/WBL 9T_tileable_0[7|3]/WBLB 9T_tileable_0[5|7]/WL
+ 9T_tileable_0[5|7]/A 9T_tileable_0[5|3]/RBL 9T_tileable_0[5|7]/VDD 9T_tileable_0[7|7]/VSS
+ 9T_tileable_0[7|7]/VSS 9T_tileable_0[5|7]/VDD 9T_tileable_0[7|7]/VSS x9T_tileable
X9T_tileable_0[6|3] 9T_tileable_0[7|3]/WBL 9T_tileable_0[7|3]/WBLB 9T_tileable_0[6|7]/WL
+ 9T_tileable_0[6|7]/A 9T_tileable_0[6|3]/RBL 9T_tileable_0[6|7]/VDD 9T_tileable_0[7|7]/VSS
+ 9T_tileable_0[7|7]/VSS 9T_tileable_0[6|7]/VDD 9T_tileable_0[7|7]/VSS x9T_tileable
X9T_tileable_0[7|3] 9T_tileable_0[7|3]/WBL 9T_tileable_0[7|3]/WBLB 9T_tileable_0[7|7]/WL
+ 9T_tileable_0[7|7]/A 9T_tileable_0[7|3]/RBL 9T_tileable_0[7|7]/VDD 9T_tileable_0[7|7]/VSS
+ 9T_tileable_0[7|3]/a_199_412# 9T_tileable_0[7|7]/VDD 9T_tileable_0[7|7]/VSS x9T_tileable
X9T_tileable_0[0|4] 9T_tileable_0[7|4]/WBL 9T_tileable_0[7|4]/WBLB 9T_tileable_0[0|7]/WL
+ 9T_tileable_0[0|7]/A 9T_tileable_0[0|4]/RBL 9T_tileable_0[0|7]/VDD 9T_tileable_0[7|7]/VSS
+ 9T_tileable_0[7|7]/VSS 9T_tileable_0[0|7]/VDD 9T_tileable_0[7|7]/VSS x9T_tileable
X9T_tileable_0[1|4] 9T_tileable_0[7|4]/WBL 9T_tileable_0[7|4]/WBLB 9T_tileable_0[1|7]/WL
+ 9T_tileable_0[1|7]/A 9T_tileable_0[1|4]/RBL 9T_tileable_0[1|7]/VDD 9T_tileable_0[7|7]/VSS
+ 9T_tileable_0[7|7]/VSS 9T_tileable_0[1|7]/VDD 9T_tileable_0[7|7]/VSS x9T_tileable
X9T_tileable_0[2|4] 9T_tileable_0[7|4]/WBL 9T_tileable_0[7|4]/WBLB 9T_tileable_0[2|7]/WL
+ 9T_tileable_0[2|7]/A 9T_tileable_0[2|4]/RBL 9T_tileable_0[2|7]/VDD 9T_tileable_0[7|7]/VSS
+ 9T_tileable_0[7|7]/VSS 9T_tileable_0[2|7]/VDD 9T_tileable_0[7|7]/VSS x9T_tileable
X9T_tileable_0[3|4] 9T_tileable_0[7|4]/WBL 9T_tileable_0[7|4]/WBLB 9T_tileable_0[3|7]/WL
+ 9T_tileable_0[3|7]/A 9T_tileable_0[3|4]/RBL 9T_tileable_0[3|7]/VDD 9T_tileable_0[7|7]/VSS
+ 9T_tileable_0[7|7]/VSS 9T_tileable_0[3|7]/VDD 9T_tileable_0[7|7]/VSS x9T_tileable
X9T_tileable_0[4|4] 9T_tileable_0[7|4]/WBL 9T_tileable_0[7|4]/WBLB 9T_tileable_0[4|7]/WL
+ 9T_tileable_0[4|7]/A 9T_tileable_0[4|4]/RBL 9T_tileable_0[4|7]/VDD 9T_tileable_0[7|7]/VSS
+ 9T_tileable_0[7|7]/VSS 9T_tileable_0[4|7]/VDD 9T_tileable_0[7|7]/VSS x9T_tileable
X9T_tileable_0[5|4] 9T_tileable_0[7|4]/WBL 9T_tileable_0[7|4]/WBLB 9T_tileable_0[5|7]/WL
+ 9T_tileable_0[5|7]/A 9T_tileable_0[5|4]/RBL 9T_tileable_0[5|7]/VDD 9T_tileable_0[7|7]/VSS
+ 9T_tileable_0[7|7]/VSS 9T_tileable_0[5|7]/VDD 9T_tileable_0[7|7]/VSS x9T_tileable
X9T_tileable_0[6|4] 9T_tileable_0[7|4]/WBL 9T_tileable_0[7|4]/WBLB 9T_tileable_0[6|7]/WL
+ 9T_tileable_0[6|7]/A 9T_tileable_0[6|4]/RBL 9T_tileable_0[6|7]/VDD 9T_tileable_0[7|7]/VSS
+ 9T_tileable_0[7|7]/VSS 9T_tileable_0[6|7]/VDD 9T_tileable_0[7|7]/VSS x9T_tileable
X9T_tileable_0[7|4] 9T_tileable_0[7|4]/WBL 9T_tileable_0[7|4]/WBLB 9T_tileable_0[7|7]/WL
+ 9T_tileable_0[7|7]/A 9T_tileable_0[7|4]/RBL 9T_tileable_0[7|7]/VDD 9T_tileable_0[7|7]/VSS
+ 9T_tileable_0[7|4]/a_199_412# 9T_tileable_0[7|7]/VDD 9T_tileable_0[7|7]/VSS x9T_tileable
X9T_tileable_0[0|5] 9T_tileable_0[7|5]/WBL 9T_tileable_0[7|5]/WBLB 9T_tileable_0[0|7]/WL
+ 9T_tileable_0[0|7]/A 9T_tileable_0[0|5]/RBL 9T_tileable_0[0|7]/VDD 9T_tileable_0[7|7]/VSS
+ 9T_tileable_0[7|7]/VSS 9T_tileable_0[0|7]/VDD 9T_tileable_0[7|7]/VSS x9T_tileable
X9T_tileable_0[1|5] 9T_tileable_0[7|5]/WBL 9T_tileable_0[7|5]/WBLB 9T_tileable_0[1|7]/WL
+ 9T_tileable_0[1|7]/A 9T_tileable_0[1|5]/RBL 9T_tileable_0[1|7]/VDD 9T_tileable_0[7|7]/VSS
+ 9T_tileable_0[7|7]/VSS 9T_tileable_0[1|7]/VDD 9T_tileable_0[7|7]/VSS x9T_tileable
X9T_tileable_0[2|5] 9T_tileable_0[7|5]/WBL 9T_tileable_0[7|5]/WBLB 9T_tileable_0[2|7]/WL
+ 9T_tileable_0[2|7]/A 9T_tileable_0[2|5]/RBL 9T_tileable_0[2|7]/VDD 9T_tileable_0[7|7]/VSS
+ 9T_tileable_0[7|7]/VSS 9T_tileable_0[2|7]/VDD 9T_tileable_0[7|7]/VSS x9T_tileable
X9T_tileable_0[3|5] 9T_tileable_0[7|5]/WBL 9T_tileable_0[7|5]/WBLB 9T_tileable_0[3|7]/WL
+ 9T_tileable_0[3|7]/A 9T_tileable_0[3|5]/RBL 9T_tileable_0[3|7]/VDD 9T_tileable_0[7|7]/VSS
+ 9T_tileable_0[7|7]/VSS 9T_tileable_0[3|7]/VDD 9T_tileable_0[7|7]/VSS x9T_tileable
X9T_tileable_0[4|5] 9T_tileable_0[7|5]/WBL 9T_tileable_0[7|5]/WBLB 9T_tileable_0[4|7]/WL
+ 9T_tileable_0[4|7]/A 9T_tileable_0[4|5]/RBL 9T_tileable_0[4|7]/VDD 9T_tileable_0[7|7]/VSS
+ 9T_tileable_0[7|7]/VSS 9T_tileable_0[4|7]/VDD 9T_tileable_0[7|7]/VSS x9T_tileable
X9T_tileable_0[5|5] 9T_tileable_0[7|5]/WBL 9T_tileable_0[7|5]/WBLB 9T_tileable_0[5|7]/WL
+ 9T_tileable_0[5|7]/A 9T_tileable_0[5|5]/RBL 9T_tileable_0[5|7]/VDD 9T_tileable_0[7|7]/VSS
+ 9T_tileable_0[7|7]/VSS 9T_tileable_0[5|7]/VDD 9T_tileable_0[7|7]/VSS x9T_tileable
X9T_tileable_0[6|5] 9T_tileable_0[7|5]/WBL 9T_tileable_0[7|5]/WBLB 9T_tileable_0[6|7]/WL
+ 9T_tileable_0[6|7]/A 9T_tileable_0[6|5]/RBL 9T_tileable_0[6|7]/VDD 9T_tileable_0[7|7]/VSS
+ 9T_tileable_0[7|7]/VSS 9T_tileable_0[6|7]/VDD 9T_tileable_0[7|7]/VSS x9T_tileable
X9T_tileable_0[7|5] 9T_tileable_0[7|5]/WBL 9T_tileable_0[7|5]/WBLB 9T_tileable_0[7|7]/WL
+ 9T_tileable_0[7|7]/A 9T_tileable_0[7|5]/RBL 9T_tileable_0[7|7]/VDD 9T_tileable_0[7|7]/VSS
+ 9T_tileable_0[7|5]/a_199_412# 9T_tileable_0[7|7]/VDD 9T_tileable_0[7|7]/VSS x9T_tileable
X9T_tileable_0[0|6] 9T_tileable_0[7|6]/WBL 9T_tileable_0[7|6]/WBLB 9T_tileable_0[0|7]/WL
+ 9T_tileable_0[0|7]/A 9T_tileable_0[0|6]/RBL 9T_tileable_0[0|7]/VDD 9T_tileable_0[7|7]/VSS
+ 9T_tileable_0[7|7]/VSS 9T_tileable_0[0|7]/VDD 9T_tileable_0[7|7]/VSS x9T_tileable
X9T_tileable_0[1|6] 9T_tileable_0[7|6]/WBL 9T_tileable_0[7|6]/WBLB 9T_tileable_0[1|7]/WL
+ 9T_tileable_0[1|7]/A 9T_tileable_0[1|6]/RBL 9T_tileable_0[1|7]/VDD 9T_tileable_0[7|7]/VSS
+ 9T_tileable_0[7|7]/VSS 9T_tileable_0[1|7]/VDD 9T_tileable_0[7|7]/VSS x9T_tileable
X9T_tileable_0[2|6] 9T_tileable_0[7|6]/WBL 9T_tileable_0[7|6]/WBLB 9T_tileable_0[2|7]/WL
+ 9T_tileable_0[2|7]/A 9T_tileable_0[2|6]/RBL 9T_tileable_0[2|7]/VDD 9T_tileable_0[7|7]/VSS
+ 9T_tileable_0[7|7]/VSS 9T_tileable_0[2|7]/VDD 9T_tileable_0[7|7]/VSS x9T_tileable
X9T_tileable_0[3|6] 9T_tileable_0[7|6]/WBL 9T_tileable_0[7|6]/WBLB 9T_tileable_0[3|7]/WL
+ 9T_tileable_0[3|7]/A 9T_tileable_0[3|6]/RBL 9T_tileable_0[3|7]/VDD 9T_tileable_0[7|7]/VSS
+ 9T_tileable_0[7|7]/VSS 9T_tileable_0[3|7]/VDD 9T_tileable_0[7|7]/VSS x9T_tileable
X9T_tileable_0[4|6] 9T_tileable_0[7|6]/WBL 9T_tileable_0[7|6]/WBLB 9T_tileable_0[4|7]/WL
+ 9T_tileable_0[4|7]/A 9T_tileable_0[4|6]/RBL 9T_tileable_0[4|7]/VDD 9T_tileable_0[7|7]/VSS
+ 9T_tileable_0[7|7]/VSS 9T_tileable_0[4|7]/VDD 9T_tileable_0[7|7]/VSS x9T_tileable
X9T_tileable_0[5|6] 9T_tileable_0[7|6]/WBL 9T_tileable_0[7|6]/WBLB 9T_tileable_0[5|7]/WL
+ 9T_tileable_0[5|7]/A 9T_tileable_0[5|6]/RBL 9T_tileable_0[5|7]/VDD 9T_tileable_0[7|7]/VSS
+ 9T_tileable_0[7|7]/VSS 9T_tileable_0[5|7]/VDD 9T_tileable_0[7|7]/VSS x9T_tileable
X9T_tileable_0[6|6] 9T_tileable_0[7|6]/WBL 9T_tileable_0[7|6]/WBLB 9T_tileable_0[6|7]/WL
+ 9T_tileable_0[6|7]/A 9T_tileable_0[6|6]/RBL 9T_tileable_0[6|7]/VDD 9T_tileable_0[7|7]/VSS
+ 9T_tileable_0[7|7]/VSS 9T_tileable_0[6|7]/VDD 9T_tileable_0[7|7]/VSS x9T_tileable
X9T_tileable_0[7|6] 9T_tileable_0[7|6]/WBL 9T_tileable_0[7|6]/WBLB 9T_tileable_0[7|7]/WL
+ 9T_tileable_0[7|7]/A 9T_tileable_0[7|6]/RBL 9T_tileable_0[7|7]/VDD 9T_tileable_0[7|7]/VSS
+ 9T_tileable_0[7|6]/a_199_412# 9T_tileable_0[7|7]/VDD 9T_tileable_0[7|7]/VSS x9T_tileable
X9T_tileable_0[0|7] 9T_tileable_0[7|7]/WBL 9T_tileable_0[7|7]/WBLB 9T_tileable_0[0|7]/WL
+ 9T_tileable_0[0|7]/A 9T_tileable_0[0|7]/RBL 9T_tileable_0[0|7]/VDD 9T_tileable_0[7|7]/VSS
+ 9T_tileable_0[7|7]/VSS 9T_tileable_0[0|7]/VDD 9T_tileable_0[7|7]/VSS x9T_tileable
X9T_tileable_0[1|7] 9T_tileable_0[7|7]/WBL 9T_tileable_0[7|7]/WBLB 9T_tileable_0[1|7]/WL
+ 9T_tileable_0[1|7]/A 9T_tileable_0[1|7]/RBL 9T_tileable_0[1|7]/VDD 9T_tileable_0[7|7]/VSS
+ 9T_tileable_0[7|7]/VSS 9T_tileable_0[1|7]/VDD 9T_tileable_0[7|7]/VSS x9T_tileable
X9T_tileable_0[2|7] 9T_tileable_0[7|7]/WBL 9T_tileable_0[7|7]/WBLB 9T_tileable_0[2|7]/WL
+ 9T_tileable_0[2|7]/A 9T_tileable_0[2|7]/RBL 9T_tileable_0[2|7]/VDD 9T_tileable_0[7|7]/VSS
+ 9T_tileable_0[7|7]/VSS 9T_tileable_0[2|7]/VDD 9T_tileable_0[7|7]/VSS x9T_tileable
X9T_tileable_0[3|7] 9T_tileable_0[7|7]/WBL 9T_tileable_0[7|7]/WBLB 9T_tileable_0[3|7]/WL
+ 9T_tileable_0[3|7]/A 9T_tileable_0[3|7]/RBL 9T_tileable_0[3|7]/VDD 9T_tileable_0[7|7]/VSS
+ 9T_tileable_0[7|7]/VSS 9T_tileable_0[3|7]/VDD 9T_tileable_0[7|7]/VSS x9T_tileable
X9T_tileable_0[4|7] 9T_tileable_0[7|7]/WBL 9T_tileable_0[7|7]/WBLB 9T_tileable_0[4|7]/WL
+ 9T_tileable_0[4|7]/A 9T_tileable_0[4|7]/RBL 9T_tileable_0[4|7]/VDD 9T_tileable_0[7|7]/VSS
+ 9T_tileable_0[7|7]/VSS 9T_tileable_0[4|7]/VDD 9T_tileable_0[7|7]/VSS x9T_tileable
X9T_tileable_0[5|7] 9T_tileable_0[7|7]/WBL 9T_tileable_0[7|7]/WBLB 9T_tileable_0[5|7]/WL
+ 9T_tileable_0[5|7]/A 9T_tileable_0[5|7]/RBL 9T_tileable_0[5|7]/VDD 9T_tileable_0[7|7]/VSS
+ 9T_tileable_0[7|7]/VSS 9T_tileable_0[5|7]/VDD 9T_tileable_0[7|7]/VSS x9T_tileable
X9T_tileable_0[6|7] 9T_tileable_0[7|7]/WBL 9T_tileable_0[7|7]/WBLB 9T_tileable_0[6|7]/WL
+ 9T_tileable_0[6|7]/A 9T_tileable_0[6|7]/RBL 9T_tileable_0[6|7]/VDD 9T_tileable_0[7|7]/VSS
+ 9T_tileable_0[7|7]/VSS 9T_tileable_0[6|7]/VDD 9T_tileable_0[7|7]/VSS x9T_tileable
X9T_tileable_0[7|7] 9T_tileable_0[7|7]/WBL 9T_tileable_0[7|7]/WBLB 9T_tileable_0[7|7]/WL
+ 9T_tileable_0[7|7]/A 9T_tileable_0[7|7]/RBL 9T_tileable_0[7|7]/VDD 9T_tileable_0[7|7]/VSS
+ 9T_tileable_0[7|7]/a_199_412# 9T_tileable_0[7|7]/VDD 9T_tileable_0[7|7]/VSS x9T_tileable
.ends
