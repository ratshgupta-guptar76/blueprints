* NGSPICE file created from 9T.ext - technology: gf180mcuD

.subckt x9T
X0 a_63_n292# a_n20_n248# a_119_2# w_n99_n78# pfet_03v3 ad=0.1804p pd=1.7u as=0.1144p ps=0.96u w=0.44u l=0.28u
X1 a_119_n248# a_63_n292# a_n20_n248# VSUBS nfet_03v3 ad=83.55f pd=0.91u as=0.1626p ps=1.73u w=0.22u l=0.28u
X2 a_63_n292# a_n20_n248# a_119_n248# VSUBS nfet_03v3 ad=0.1637p pd=1.74u as=83.55f ps=0.91u w=0.22u l=0.28u
X3 a_119_2# a_63_n292# a_n20_n248# w_n99_n78# pfet_03v3 ad=0.1144p pd=0.96u as=0.1804p ps=1.7u w=0.44u l=0.28u
.ends
