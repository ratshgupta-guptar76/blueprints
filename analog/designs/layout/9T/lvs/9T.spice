* NGSPICE file created from 9T.ext - technology: gf180mcuD

.subckt x9T Q QB A RBL WL VDD VSS WBLB WBL
X0 Q QB VDD w_n100_n78# pfet_03v3 ad=0.1804p pd=1.7u as=0.1144p ps=0.96u w=0.44u l=0.28u
X1 RBL QB A w_n100_n78# pfet_03v3 ad=0.2024p pd=1.8u as=0.2024p ps=1.8u w=0.44u l=0.28u
X2 Q WL WBL VSUBS nfet_03v3 ad=0.1286p pd=1.155u as=0.1312p ps=1.46u w=0.32u l=0.28u
X3 VSS Q QB VSUBS nfet_03v3 ad=88.2f pd=0.94u as=0.1286p ps=1.155u w=0.22u l=0.28u
X4 Q QB VSS VSUBS nfet_03v3 ad=0.1286p pd=1.155u as=88.2f ps=0.94u w=0.22u l=0.28u
X5 VSS QB RBL VSUBS nfet_03v3 ad=0.138p pd=1.58u as=85.89999f ps=0.915u w=0.22u l=0.28u
X6 RBL Q A VSUBS nfet_03v3 ad=85.89999f pd=0.915u as=0.1516p ps=1.64u w=0.22u l=0.28u
X7 VDD Q QB w_n100_n78# pfet_03v3 ad=0.1144p pd=0.96u as=0.1804p ps=1.7u w=0.44u l=0.28u
X8 QB WL WBLB VSUBS nfet_03v3 ad=0.1286p pd=1.155u as=0.1312p ps=1.46u w=0.32u l=0.28u
.ends
