** sch_path: /workspace/analog/designs/9T_03v3.sch
.subckt 9T_03v3 RBL VSS VDD WL WBL WBLB Q QB A
*.PININFO RBL:O VSS:I VDD:I WL:I WBL:I WBLB:I Q:O QB:O A:I
M1 RBL QB VSS VSS nfet_03v3 L=0.28 W=0.22 nf=1
PD1 QB Q VSS VSS nfet_03v3 L=0.28 W=0.22 nf=1
PU1 QB Q VDD VDD pfet_03v3 L=0.28 W=0.44 nf=1
AX1 WBLB WL QB QB nfet_03v3 L=0.28 W=0.32 nf=1
PU2 Q QB VDD VDD pfet_03v3 L=0.28 W=0.44 nf=1
PD2 Q QB VSS VSS nfet_03v3 L=0.28 W=0.22 nf=1
AX2 WBL WL Q Q nfet_03v3 L=0.28 W=0.32 nf=1
M2 RBL QB A A pfet_03v3 L=0.28 W=0.44 nf=1
M3 A Q RBL VSS nfet_03v3 L=0.28 W=0.22 nf=1
.ends
