* Extracted by KLayout with GF180MCU LVS runset on : 04/08/2026 03:06

* cell sram_6t
* pin Q
* pin QB
* pin VDD
* pin VSS
* pin WBL
* pin WBLB
* pin WL
.SUBCKT sram_6t Q QB VDD VSS WBL WBLB WL
* device instance $1 r0 *1 0.15,2.45 pfet_03v3
M$1 VDD QB Q VDD pfet_03v3 L=0.3U W=0.6U AS=0.36P AD=0.36P PS=2.4U PD=1.8U
* device instance $2 r0 *1 1.65,2.45 pfet_03v3
M$2 QB Q VDD VDD pfet_03v3 L=0.3U W=0.6U AS=0.36P AD=0.36P PS=1.8U PD=2.4U
* device instance $3 r0 *1 -0.35,-0.55 nfet_03v3
M$3 Q WL WBL VSS nfet_03v3 L=0.3U W=0.4U AS=0.31P AD=0.3P PS=2.3U PD=1.9U
* device instance $4 r0 *1 2.15,-0.55 nfet_03v3
M$4 QB WL WBLB VSS nfet_03v3 L=0.3U W=0.4U AS=0.31P AD=0.3P PS=2.3U PD=1.9U
* device instance $5 r0 *1 0.15,0.65 nfet_03v3
M$5 VSS QB Q VSS nfet_03v3 L=0.3U W=0.3U AS=0.3P AD=0.23P PS=1.9U PD=1.7U
* device instance $6 r0 *1 1.65,0.65 nfet_03v3
M$6 VSS Q QB VSS nfet_03v3 L=0.3U W=0.3U AS=0.3P AD=0.23P PS=1.9U PD=1.7U
.ENDS sram_6t
